JFET2 model_temp junction and channel response
* Provenance: original Sansho R14 circuit.
* sweep: model_temp 275 300 345
.param probe=275
Vd d 0 1.8
Vg g 0 -.6 ac 1
J1 d g 0 dev
.model dev njf(level=2 beta=0.7m vto=-1.6 cgs=4p cgd=1p temp={probe})
.dc Vg -3 .35 .025
.save i(Vd) i(Vg)
.end
