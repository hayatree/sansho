Temperature mapping of TNF
* Provenance: original Sansho R15 circuit.
* sweep: tnf -.001 0 .001
.param probe=-.001
Vc c 0 2
Vb b 0 .70
Q1 c b 0 dev
.model dev npn(level=4 is=1e-16 ibei=2e-18 iben=2e-13 nen=2 tnom=20 tnf={probe})
.dc temp -20 100 10
.save i(Vc) i(Vb)
.end
