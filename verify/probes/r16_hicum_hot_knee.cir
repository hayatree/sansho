Thermal change of the drift velocity in critical current
* Provenance: original Sansho R16 circuit.
* sweep: hot_knee -.003 0 .003
.param probe=-.003
Vc c 0 1
Vb b 0 .72
Q1 c b 0 0 dev
.model dev npn(level=8 alvs={probe} vlim=.12 t0=2p tef0=50p)
.dc temp -30 120 10
.save i(Vc) i(Vb)
.end
