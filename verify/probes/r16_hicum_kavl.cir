Avalanche carrier feedback at finite multiplication
* Provenance: original Sansho R16 circuit.
* sweep: kavl 0 .5 2
.param probe=0
Vc c 0 1
Vb b 0 .76
Q1 c b 0 0 dev
.model dev npn(level=8 favl=.05 cjci0=10f qavl=10f kavl={probe} vlim=.15)
.dc Vc .7 5 .05
.save i(Vb) i(Vc)
.end
