Unresolved ZETACX mapping on a hot collector with finite access resistance
* Provenance: original Sansho R16 circuit.
* sweep: zetacx 0 1 2
.param probe=0
Vc c 0 1
Vb b 0 .72
Q1 c b 0 0 dev
.model dev npn(level=8 zetacx={probe} rcx=30 ibcxs=1e-16 cjcx0=20f)
.dc temp -30 120 10
.save i(Vc) i(Vb)
.end
