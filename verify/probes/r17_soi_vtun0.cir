SOI body junction sweep varying vtun0
* Provenance: original Sansho R17 circuit with synthetic parameters.
* sweep: vtun0 .6 1 2
.param probe=.6
Vd d 0 .45
Vg g 0 .15
Ve e 0 0
Vb b 0 .1
M1 d g 0 e b dev l=.48u w=2.4u
.model dev nmos(level=10 version=4.4 tox=4.6n tsi=75n tbox=105n nch=1.1e17 k1=.42 vth0=.48 u0=.047 istun=.04 ntun=2 vtun0={probe})
.dc Vb -.45 .57 .03
.save i(Vb) i(Vd)
.end
