Low-voltage critical-current smoothing
* Provenance: original Sansho R16 circuit.
* sweep: aick .001 .02 .08
.param probe=.001
Vc c 0 1
Vb b 0 .79
Q1 c b 0 0 dev
.model dev npn(level=8 aick={probe} tef0=12p)
.dc Vc -.05 2 .025
.save i(Vc) i(Vb)
.end
