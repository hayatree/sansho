Temperature coefficient of emitter access resistance
* Provenance: original Sansho R16 circuit.
* sweep: zetare 0 1 2
.param probe=0
Vc c 0 1
Vb b 0 .72
Q1 c b 0 0 dev
.model dev npn(level=8 zetare={probe} re=12)
.dc temp -30 120 10
.save i(Vc) i(Vb)
.end
