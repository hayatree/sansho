Temperature mapping of EAIC
* Provenance: original Sansho R15 circuit.
* sweep: eaic .85 1 1.15
.param probe=.85
Vc c 0 .04
Vb b 0 .70
Q1 c b 0 dev
.model dev npn(level=4 is=1e-16 ibei=2e-18 iben=2e-13 nen=2 tnom=20 ibci=1e-15 eaic={probe})
.dc temp -20 100 10
.save i(Vc) i(Vb)
.end
