Critical current transition shape
* Provenance: original Sansho R16 circuit.
* sweep: delck 1 2 4
.param probe=1
Vc c 0 1
Vb b 0 .79
Q1 c b 0 0 dev
.model dev npn(level=8 delck={probe} tef0=12p)
.dc Vc -.05 2 .025
.save i(Vc) i(Vb)
.end
