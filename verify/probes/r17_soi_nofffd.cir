Buried-oxide bias transfer varying nofffd
* Provenance: original Sansho R17 circuit with synthetic parameters.
* sweep: nofffd .6 1 2
.param probe=.6
Vd d 0 0.95
Vg g 0 .8
Ve e 0 0
M1 d g 0 e dev l=.48u w=2.4u
.model dev nmos(level=10 version=4.4 tox=4.6n tsi=35n tbox=105n nch=1.1e17 k1=.42 vth0=.48 u0=.047 soimod=1 nofffd={probe})
.dc Ve -1.5 1.5 .15 Vg .45 .95 .25
.save i(Vd)
.end
