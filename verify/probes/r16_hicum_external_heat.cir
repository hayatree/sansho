Heat at an exported thermal pin with an external path
* Provenance: original Sansho R16 circuit.
* sweep: external_heat 0 200 500
.param probe=0
Vc c 0 1.5
Vb b 0 pulse(.58 .78 1u 100n 100n 20u 50u)
Renv tj 0 500
Q1 c b 0 0 tj dev
.model dev npn(level=8 flsh=2 rth={probe} re=2)
.tran .25u 45u
.save v(tj) i(Vc) i(Vb)
.end
