Collector storage through the Kirk transition
* Provenance: original Sansho R16 circuit.
* sweep: thcs 0 12p 60p
.param probe=0
Vc c 0 1
Vb b 0 .76 ac 1
Q1 c b 0 0 dev
.model dev npn(level=8 thcs={probe} vlim=.12)
.ac dec 4 1meg 100G
.save i(Vc) i(Vb)
.end
