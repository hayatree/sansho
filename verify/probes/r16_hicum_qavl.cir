Weak avalanche onset versus the charge scale
* Provenance: original Sansho R16 circuit.
* sweep: qavl 3f 10f 30f
.param probe=3f
Vc c 0 1
Vb b 0 .76
Q1 c b 0 0 dev
.model dev npn(level=8 favl=.05 qavl={probe} cjci0=10f)
.dc Vc .7 5 .05
.save i(Vb) i(Vc)
.end
