Five RC-loaded inverting gain stages
* Provenance: original Sansho oscillator probe for R22.
* sansho-verify: pss-ng v(out)
B0 0 out I={-0.002*tanh(4*v(d))}
R0 out 0 500
C0 out 0 4p ic=0.7
B1 0 a I={-0.002*tanh(4*v(out))}
R1 a 0 500
C1 a 0 4p ic=0
B2 0 b I={-0.002*tanh(4*v(a))}
R2 b 0 500
C2 b 0 4p ic=0
B3 0 c I={-0.002*tanh(4*v(b))}
R3 c 0 500
C3 c 0 4p ic=0
B4 0 d I={-0.002*tanh(4*v(c))}
R4 d 0 500
C4 d 0 4p ic=0
.pss 55meg 300n out 128 8 50 0.005 uic
.end
