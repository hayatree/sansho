BSIM1 MUS bias and geometry response
* Provenance: original Sansho R14 circuit.
* sweep: mus 300 470 650
.param probe=300
Vd d 0 1.5
Vg g 0 1.4
Vb b 0 -.25
M1 d g 0 b dev w=4u l=1.2u
.model dev nmos(level=4 phi=.7 vfb=-.52 k1=.55 k2=.025 tox=.025 muz=470 u0=.12 u1=.1 eta=.012 vdd=3 temp=27 n0=1.45 xpart=0 mus={probe})
.dc Vg -.2 2.2 .05 Vd .2 4.4 1.4
.save i(Vg) i(Vd)
.end
