Equilibrium intrinsic conductance with one material override
* Provenance: original Sansho R20b black-box experiment.
* sweep: nv 8e18 1.04e19 3e19
* The conductance ratio to the omitted-value slab isolates the indicated material default.
.param probe=8e18
Vdrive drive 0 0
Vref drive node_ref 0
Dref node_ref 0 mref
.model mref numd level=1
+ options resistor defa=1e-8
+ x.mesh loc=0 n=1
+ x.mesh loc=2.4 n=62
+ domain num=1 material=1
+ material num=1 silicon
+ doping uniform n.type conc=1e13
+ doping uniform p.type conc=1e13
+ mobility material=1 electron majority mumax=1000
+ mobility material=1 electron minority mumax=1000
+ mobility material=1 hole majority mumax=500
+ mobility material=1 hole minority mumax=500
+ end
Vtest drive node_test 0
Dtest node_test 0 mtest
.model mtest numd level=1
+ options resistor defa=1e-8
+ x.mesh loc=0 n=1
+ x.mesh loc=2.4 n=62
+ domain num=1 material=1
+ material num=1 silicon nv={probe}
+ doping uniform n.type conc=1e13
+ doping uniform p.type conc=1e13
+ mobility material=1 electron majority mumax=1000
+ mobility material=1 electron minority mumax=1000
+ mobility material=1 hole majority mumax=500
+ mobility material=1 hole minority mumax=500
+ end
.options itl1=200 itl2=120 reltol=1e-5 abstol=1e-15
.dc Vdrive -0.01 0.01 0.005
.save i(vref) i(vtest)
.end
