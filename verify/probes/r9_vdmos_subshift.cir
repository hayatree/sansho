Subthreshold intercept at nominal temperature
* Provenance: original Sansho R9b black-box experiment.
* sweep: -0.04 0 0.04
.param probe=-0.04
Vd d 0 3
Vg g 0 1
M1 d g 0 p
.model p vdmos(vto=2 kp=0.8 ksubthres=0.08 subshift={probe})
.dc Vg 1.3 3.2 0.025
.save i(Vd)
.end
