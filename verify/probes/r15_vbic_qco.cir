Complex terminal admittance with variable QCO
* Provenance: original Sansho R15 circuit.
* sweep: qco 0 1p 10p
.param probe=0
Vc c 0 .12
Vb b 0 .70 ac 1
Q1 c b 0 dev
.model dev npn(level=4 is=1e-16 ibei=1e-18 rbi=80 rci=15 gamm=1e-10 tf=.4n cje=1p cjc=.3p itf=.1m vtf=1 qco={probe})
.ac dec 8 100k 10G
.save i(Vc) i(Vb)
.end
