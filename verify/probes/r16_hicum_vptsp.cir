External substrate junction punch-through in reverse bias
* Provenance: original Sansho R16 circuit.
* sweep: vptsp .2 1 10
.param probe=.2
Vc c 0 .15 ac 1
Vb b 0 .76
Vs s 0 -.2
Q1 c b 0 s dev
.model dev npn(level=8 cscp0=1p vptsp={probe})
.ac dec 4 100k 10G
.save i(Vs) i(Vb) i(Vc)
.end
