Parallel multiplicity scaling
* Provenance: original Sansho R16 circuit.
* sweep: m 1 2 4
.param probe=1
Vc c 0 1
Vb b 0 .72
Q1 c b 0 0 dev m={probe}
.model dev npn(level=8 t0=8p re=1 rbi0=10)
.dc Vb .4 .88 .02
.save i(Vc) i(Vb)
.end
