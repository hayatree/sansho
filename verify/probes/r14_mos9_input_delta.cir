MOS9 drain family versus DELTA with fixed MOS3 control
* Provenance: original Sansho R14 circuit.
* sweep: delta 0 .5 2
.param probe=0
* The 44.2 parser rejects INPUT_DELTA on the model card. Sweep a supported input.
Vd d 0 1.5
Vg g 0 1.4
Vb b 0 -.25
M1 d g 0 b dev w=4u l=1.2u
Ecopy ctrlref 0 d 0 1
M0 ctrlref g 0 b base w=4u l=1.2u
.model dev nmos(level=9 vto=0.65 kp=65u phi=.7 gamma=.4 theta=.12 vmax=9e4 nsub=2e16 xj=.14u delta={probe})
.model base nmos(level=3 vto=0.65 kp=65u phi=.7 gamma=.4 theta=.12 vmax=9e4 nsub=2e16 xj=.14u)
.dc Vd .02 2.82 .05 Vg .8 2 .4
.save i(Vd) i(Ecopy)
.end
