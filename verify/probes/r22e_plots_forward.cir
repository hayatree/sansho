Mixed analysis plot order, forward
* Provenance: original Sansho R22e black-box plot-order probe.
Vdrive in 0 dc 0.4 ac 1 distof1 1m portnum=1 z0=50 sin(0.4 0.2 1k)
Rdrive in sense 1k
Rfeed sense out 1k
Clead sense out 10n
Rload out 0 2k
Ddet out 0 dj
.model dj d(is=1e-14)
.four 1k v(out)
.meas tran peak max v(out)
.tran 10u 4m
.sp lin 3 1k 2k
.tf v(out) Vdrive
.pz sense 0 out 0 vol pz
.noise v(out) Vdrive lin 3 1k 2k
.op
.disto lin 3 1k 2k
.sens v(out)
.dc Vdrive 0.3 0.5 0.1
.ac lin 2 700 2.6k
.end
