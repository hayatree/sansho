Measure the DC drop across the internal base resistance while varying FDQR0
* Provenance: original Sansho R16b black-box experiment.
* sweep: rbi_partition 0 .5 1
.param probe=0
Vb b 0 .72
Vc c 0 1
Q1 c b 0 0 n
.model n npn(level=8 t0=200p rbi0=200 fdqr0={probe})
.dc Vb .58 .88 .01
.save i(Vb) i(Vc)
.end
