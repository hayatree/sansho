BSIM2 WVFB bias and geometry response
* Provenance: original Sansho R14 circuit.
* sweep: wvfb -.2u 0 .2u
.param probe=-.2u
Vd d 0 1.5
Vg g 0 1.4
Vb b 0 -.25
M1 d g 0 b dev w=4u l=1.2u
Esense ds 0 d 0 1
M2 ds g 0 b dev w=8u l=1.2u
.model dev nmos(level=5 phi=.7 vfb=-.52 k1=.55 k2=.025 tox=.025 mu0=470 ua0=.12 ub0=.02 u10=.1 eta0=.012 vdd=3 temp=27 n0=1.45 xpart=0 wvfb={probe})
.dc Vg -.2 2.2 .05 Vd .2 3 1.4
.save i(Vd) i(Esense)
.end
