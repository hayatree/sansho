Isolated silicon tempmob switch
* Provenance: original Sansho numerical-device fixture.
* sweep: temperature 85
Vdrive a 0 0
Vref a r 0
Vtest a t 0
Dref r 0 reference
Dtest t 0 active
.temp 85
.model reference numd level=1
+ options defa=1e-10 diode
+ x.mesh location=0 number=1
+ x.mesh location=2.4 number=62
+ domain number=1 material=1
+ material number=1 silicon tn=2n tp=3n
+ doping uniform n.type conc=1e+16
+ doping uniform p.type conc=2e+16 x.high=1.2
+ end
.model active numd level=1
+ options defa=1e-10 diode
+ x.mesh location=0 number=1
+ x.mesh location=2.4 number=62
+ domain number=1 material=1
+ material number=1 silicon tn=2n tp=3n
+ doping uniform n.type conc=1e+16
+ doping uniform p.type conc=2e+16 x.high=1.2
+ models tempmob
+ end
.options itl1=150 itl2=100
.dc Vdrive 0.2 0.68 0.04
.save i(vref) i(vtest)
.end
