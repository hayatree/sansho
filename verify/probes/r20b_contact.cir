Minority diffusion length to the ohmic boundary
* Provenance: original Sansho R20b black-box experiment.
* sweep: extent 2 4 8 16
* The junction stays at 1 um. Only the right neutral slab and its contact move.
.param probe=2
Vdrive drive 0 0
Vtest drive node_test 0
Dtest node_test 0 mtest
.model mtest numd level=1
+ options diode defa=1e-10
+ x.mesh loc=0 n=1
+ x.mesh loc=1.5 n=80
+ x.mesh loc={probe} n=150
+ domain num=1 material=1
+ material num=1 silicon
+ doping uniform p.type conc=1e16 x.high=1
+ doping uniform n.type conc=1e16 x.low=1
+ mobility material=1 electron majority mumax=1000
+ mobility material=1 electron minority mumax=1000
+ mobility material=1 hole majority mumax=500
+ mobility material=1 hole minority mumax=500
+ end
.options itl1=200 itl2=120 reltol=1e-5 abstol=1e-15
.dc Vdrive 0.30 0.54 0.03
.save i(vtest)
.end
