Pocket contribution to drain conductance
* Provenance: original Sansho R17 circuit with synthetic parameters.
* sweep: pdits 0 .1 1
.param probe=0
Vd d 0 0.95
Vg g 0 .8
Ve e 0 0
M1 d g 0 e 0 dev l=.48u w=2.4u
.model dev nmos(level=10 version=4.4 tox=4.6n tsi=75n tbox=105n nch=1.1e17 k1=.42 vth0=.48 u0=.047 pdits={probe} pditsd=.5)
.dc Vd .1 1.8 .05
.save i(Vd) @m1[gds]
.end
