Initial terminal voltage and arrival at a quiescent load
* Provenance: original Sansho R18 circuit.
* sweep: initial 0 .5 1
* known-difference: .5 1 | v(near) v(far) i(vin)
.param probe=0
Vin src 0 dc 0 ac 1 pulse(0 1 1n .1n .1n 45n 100n)
Rs src near 50
Y1 near 0 far 0 wire
.model wire txl(r=16 l=250n g=.8m c=100p length=1)
Rl far 0 50
.ic v(near)={probe}
.tran .05n 16n uic
.save v(near) v(far) i(Vin)
.end
