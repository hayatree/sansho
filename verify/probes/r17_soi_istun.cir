SOI body junction sweep varying istun
* Provenance: original Sansho R17 circuit with synthetic parameters.
* sweep: istun 0 .01 .1
.param probe=0
Vd d 0 .45
Vg g 0 .15
Ve e 0 0
Vb b 0 .1
M1 d g 0 e b dev l=.48u w=2.4u
.model dev nmos(level=10 version=4.4 tox=4.6n tsi=75n tbox=105n nch=1.1e17 k1=.42 vth0=.48 u0=.047 isdif=0 isbjt=0 isrec=0 vtun0=1.3 ntun=3 istun={probe})
.dc Vb -.45 .57 .03
.save i(Vb) i(Vd)
.end
