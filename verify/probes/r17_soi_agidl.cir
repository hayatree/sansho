Off-state film generation at both drain polarities varying agidl
* Provenance: original Sansho R17 circuit with synthetic parameters.
* sweep: agidl 0 1e-9 1e-8
.param probe=0
Vd d 0 1
Vg g 0 -.5
Ve e 0 0
Vb b 0 -1
M1 d g 0 e b dev l=.48u w=2.4u
.model dev nmos(level=10 version=4.4 tox=4.6n tsi=75n tbox=105n nch=1.1e17 k1=.42 vth0=.48 u0=.047 agidl={probe} agisl=1e-8 bgidl=1e8 bgisl=1e8 egidl=.25 egisl=.25)
.dc Vd -.8 1.3 .07
.save i(Vb) i(Vd)
.end
