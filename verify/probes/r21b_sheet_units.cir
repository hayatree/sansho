Signed sheet charge on both orientations of a silicon oxide interface
* Provenance: original Sansho fixture, ngspice 44 manual chapter 26.
* sweep: sheet -1e11 -2e-8 0 2e-8 1e11
.param probe=-1e11
Vsi si 0 dc 0.05 ac 1
Dsi si 0 msi
.model msi numd level=2
+ options capacitor defw=10u
+ x.mesh loc=0 n=1
+ x.mesh loc=2 n=3
+ y.mesh loc=-0.02 n=1
+ y.mesh loc=0 n=3
+ y.mesh width=0.8 h.start=0.002 h.max=0.05 ratio=1.35
+ material num=1 silicon
+ material num=2 oxide
+ domain num=1 mat=1 y.l=0
+ domain num=2 mat=2 y.h=0
+ electrode num=1 iy.h=1
+ electrode num=2 y.l=0.8
+ contact num=1 workf=4.8
+ doping uniform p.type conc=1e16 domains=1
+ interface domain=1 neighbor=2 qf={probe}
+ method ac.analysis=direct
+ end
Vox ox 0 dc 0.05 ac 1
Dox ox 0 mox
.model mox numd level=2
+ options capacitor defw=10u
+ x.mesh loc=0 n=1
+ x.mesh loc=2 n=3
+ y.mesh loc=-0.02 n=1
+ y.mesh loc=0 n=3
+ y.mesh width=0.8 h.start=0.002 h.max=0.05 ratio=1.35
+ material num=1 silicon
+ material num=2 oxide
+ domain num=1 mat=1 y.l=0
+ domain num=2 mat=2 y.h=0
+ electrode num=1 iy.h=1
+ electrode num=2 y.l=0.8
+ contact num=1 workf=4.8
+ doping uniform p.type conc=1e16 domains=1
+ interface domain=2 neighbor=1 qf={probe}
+ method ac.analysis=direct
+ end
Vclean clean 0 dc 0.05 ac 1
Dclean clean 0 mclean
.model mclean numd level=2
+ options capacitor defw=10u
+ x.mesh loc=0 n=1
+ x.mesh loc=2 n=3
+ y.mesh loc=-0.02 n=1
+ y.mesh loc=0 n=3
+ y.mesh width=0.8 h.start=0.002 h.max=0.05 ratio=1.35
+ material num=1 silicon
+ material num=2 oxide
+ domain num=1 mat=1 y.l=0
+ domain num=2 mat=2 y.h=0
+ electrode num=1 iy.h=1
+ electrode num=2 y.l=0.8
+ contact num=1 workf=4.8
+ doping uniform p.type conc=1e16 domains=1
+ method ac.analysis=direct
+ end
Vplus plus 0 dc 0.05 ac 1
Dplus plus 0 mplus
.model mplus numd level=2
+ options capacitor defw=10u
+ x.mesh loc=0 n=1
+ x.mesh loc=2 n=3
+ y.mesh loc=-0.02 n=1
+ y.mesh loc=0 n=3
+ y.mesh width=0.8 h.start=0.002 h.max=0.05 ratio=1.35
+ material num=1 silicon
+ material num=2 oxide
+ domain num=1 mat=1 y.l=0
+ domain num=2 mat=2 y.h=0
+ electrode num=1 iy.h=1
+ electrode num=2 y.l=0.8
+ contact num=1 workf=4.707204471
+ doping uniform p.type conc=1e16 domains=1
+ method ac.analysis=direct
+ end
Vminus minus 0 dc 0.05 ac 1
Dminus minus 0 mminus
.model mminus numd level=2
+ options capacitor defw=10u
+ x.mesh loc=0 n=1
+ x.mesh loc=2 n=3
+ y.mesh loc=-0.02 n=1
+ y.mesh loc=0 n=3
+ y.mesh width=0.8 h.start=0.002 h.max=0.05 ratio=1.35
+ material num=1 silicon
+ material num=2 oxide
+ domain num=1 mat=1 y.l=0
+ domain num=2 mat=2 y.h=0
+ electrode num=1 iy.h=1
+ electrode num=2 y.l=0.8
+ contact num=1 workf=4.892795529
+ doping uniform p.type conc=1e16 domains=1
+ method ac.analysis=direct
+ end
.ac lin 1 1meg 1meg
.save i(vsi) i(vox) i(vclean) i(vplus) i(vminus)
.end
