Epitaxial collector GAMM across the output knee
* Provenance: original Sansho R15 circuit.
* sweep: gamm 0 1e-11 3e-9
.param probe=0
Vc c 0 1
Ib 0 b 25u
Q1 c b 0 dev
.model dev npn(level=4 is=1e-16 ibei=1e-18 rci=16 vo=.8 hrcf=2 rcx=1.5 rbi=18 rbx=4 re=.4 vef=65 gamm={probe})
.dc Vc .02 2 .03 Ib 10u 90u 20u
.save v(b) i(Vc)
.end
