JFET2 FC capacitance at unequal end biases
* Provenance: original Sansho R14 circuit.
* sweep: fc .25 .5 .75
.param probe=.25
Vg g 0 .45 ac 1
Vd d 0 1.8
Vs s 0 0
J1 d g s core
.model core njf(level=2 cgs=3p cgd=1p vbi=1 fc={probe} is=1e-18)
.ac dec 5 1meg 100meg
.save i(Vg) i(Vd) i(Vs)
.end
