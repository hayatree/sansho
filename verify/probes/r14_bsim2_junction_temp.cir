BSIM2 ambient channel and forward-junction current
* Provenance: original Sansho R14 circuit.
* sweep: temp -20 27 85
.temp -20
Vd d 0 1.5
Vg g 0 1.4
Vb b 0 -.25
M1 d g 0 b dev ad=4p w=4u l=1.2u
.model dev nmos(level=5 phi=.7 js=2u vfb=-.52 k1=.55 tox=.025 mu0=470 ua0=.12 ub0=.02 u10=.1 eta0=.012 vdd=3 temp=27 n0=1.45 xpart=0 k2=.025)
.dc Vb -.5 .55 .025
.save i(Vb) i(Vd)
.end
