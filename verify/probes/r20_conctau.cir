Isolated silicon conctau switch
* Provenance: original Sansho numerical-device fixture.
* sweep: nominal 1
Vdrive a 0 0
Vref a r 0
Vtest a t 0
Dref r 0 reference
Dtest t 0 active
.model reference numd level=1
+ options defa=1e-10 diode
+ x.mesh location=0 number=1
+ x.mesh location=2.4 number=62
+ domain number=1 material=1
+ material number=1 silicon tn=2n tp=3n
+ doping uniform n.type conc=3e+17
+ doping uniform p.type conc=6e+17 x.high=1.2
+ models srh
+ end
.model active numd level=1
+ options defa=1e-10 diode
+ x.mesh location=0 number=1
+ x.mesh location=2.4 number=62
+ domain number=1 material=1
+ material number=1 silicon tn=2n tp=3n
+ doping uniform n.type conc=3e+17
+ doping uniform p.type conc=6e+17 x.high=1.2
+ models srh conctau
+ end
.options itl1=150 itl2=100
.dc Vdrive 0.2 0.68 0.04
.save i(vref) i(vtest)
.end
