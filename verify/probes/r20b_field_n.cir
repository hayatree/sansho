Uniform-field velocity saturation of n-type silicon
* Provenance: original Sansho R20b black-box experiment.
* sweep: vsat 5e6 1e7 2e7
* Compare v=I/(qNA) against E=V/L, with and without an explicit saturation speed.
.param probe=5e6
Vdrive drive 0 0
Voff drive node_off 0
Doff node_off 0 moff
.model moff numd level=1
+ options resistor defa=1e-8
+ x.mesh loc=0 n=1
+ x.mesh loc=2.4 n=62
+ domain num=1 material=1
+ material num=1 silicon
+ doping uniform n.type conc=1e16
+ end
Von drive node_on 0
Don node_on 0 mon
.model mon numd level=1
+ options resistor defa=1e-8
+ x.mesh loc=0 n=1
+ x.mesh loc=2.4 n=62
+ domain num=1 material=1
+ material num=1 silicon
+ doping uniform n.type conc=1e16
+ models fieldmob
+ end
Vtest drive node_test 0
Dtest node_test 0 mtest
.model mtest numd level=1
+ options resistor defa=1e-8
+ x.mesh loc=0 n=1
+ x.mesh loc=2.4 n=62
+ domain num=1 material=1
+ material num=1 silicon
+ doping uniform n.type conc=1e16
+ mobility material=1 electron majority vsat={probe}
+ models fieldmob
+ end
.options itl1=200 itl2=120 reltol=1e-5 abstol=1e-15
.dc Vdrive 0.01 5.01 0.25
.save i(voff) i(von) i(vtest)
.end
