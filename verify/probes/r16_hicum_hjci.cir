BC depletion weighting across collector bias
* Provenance: original Sansho R16 circuit.
* sweep: hjci 0 1 2
.param probe=0
Vc c 0 1
Vb b 0 .79
Q1 c b 0 0 dev
.model dev npn(level=8 hjci={probe} cjci0=8f)
.dc Vc -.05 2 .025
.save i(Vc) i(Vb)
.end
