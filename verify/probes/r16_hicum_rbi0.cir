Intrinsic sheet resistance and charge modulation
* Provenance: original Sansho R16 circuit.
* sweep: rbi0 0 20 100
.param probe=0
Vc c 0 1
Vb b 0 .72
Q1 c b 0 0 dev
.model dev npn(level=8 rbi0={probe} rbx=5 t0=20p)
.dc Vb .4 .88 .02
.save i(Vc) i(Vb)
.end
