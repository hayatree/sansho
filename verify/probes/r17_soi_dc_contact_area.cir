Gate-body tunnelling over a wider contact implant
* Provenance: original Sansho R17 circuit with synthetic parameters.
* sweep: dc_contact_area 0 .2p .8p
.param probe=0
Vd d 0 0.95
Vg g 0 .8
Ve e 0 0
Vb b 0 .1
M1 d g 0 e b dev l=.48u w=2.4u agbcpd={probe}
.model dev nmos(level=10 version=4.4 tox=2.3n tsi=75n tbox=105n nch=1.1e17 k1=.42 vth0=.48 u0=.047 igmod=1)
.dc Vg -1.5 1.5 .1
.save i(Vg) i(Vb)
.end
