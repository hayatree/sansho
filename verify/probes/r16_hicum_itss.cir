Substrate transistor collection versus forward BC bias
* Provenance: original Sansho R16 circuit.
* sweep: itss 0 1e-16 4e-16
.param probe=0
Vc c 0 .15
Vb b 0 .76
Vs s 0 -.2
Q1 c b 0 s dev
.model dev npn(level=8 itss={probe} rsu=35)
.dc Vc .01 .5 .01
.save i(Vs) i(Vb) i(Vc)
.end
