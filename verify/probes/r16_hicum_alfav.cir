Thermal dependence of avalanche
* Provenance: original Sansho R16 circuit.
* sweep: alfav -.003 0 .003
.param probe=-.003
Vc c 0 1
Vb b 0 .72
Q1 c b 0 0 dev
.model dev npn(level=8 alfav={probe} favl=.1 cjci0=10f qavl=3f)
.dc temp -30 120 10
.save i(Vc) i(Vb)
.end
