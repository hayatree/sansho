JFET2 CGS capacitance at unequal end biases
* Provenance: original Sansho R14 circuit.
* sweep: cgs 0 2p 5p
.param probe=0
Vg g 0 .45 ac 1
Vd d 0 1.8
Vs s 0 0
J1 d g s core
.model core njf(level=2 cgd=1p vbi=1 fc=.5 cgs={probe} is=1e-18)
.ac dec 5 1meg 100meg
.save i(Vg) i(Vd) i(Vs)
.end
