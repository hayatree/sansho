High-field collector limiting at zero HRCF
* Provenance: original Sansho R15b circuit.
* sweep: hrcf 0 .5 2
.param probe=0
Vc c 0 -.1
Vb b 0 .76
Q1 c b 0 dev
.model dev npn(level=4 rci=15 rcx=2 gamm=1e-9 vo=.2 hrcf={probe})
.dc Vc -.15 .3 .005
.save i(Vc) i(Vb)
.end
