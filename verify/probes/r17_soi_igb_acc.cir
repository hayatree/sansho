Accumulation gate current and its temperature prefactor
* Provenance: original Sansho R17 circuit with synthetic parameters.
* sweep: igb_acc -.35 -.8 -1.2
.param probe=-.35
Vd d 0 0.95
Vg g 0 {probe}
Ve e 0 0
Vb b 0 0
M1 d g 0 e b dev l=.48u w=2.4u
.model dev nmos(level=10 version=4.4 tox=2.2n tsi=75n tbox=105n nch=1.1e17 k1=.42 vth0=.48 u0=.047 igmod=1 alphagb2=.23)
.dc temp -20 110 10
.save i(Vg) i(Vb)
.end
