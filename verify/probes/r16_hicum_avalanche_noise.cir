Base shot spectrum as avalanche opposes injection
* Provenance: original Sansho R16 circuit.
* sweep: avalanche_noise 0 .05 .2
.param probe=0
Vc c 0 1
Vb b 0 .76 ac 1
Hread out 0 Vb 1k
Rload out 0 1k
Q1 c b 0 0 dev
.model dev npn(level=8 favl={probe} cjci0=30f qavl=2f)
.noise v(out) Vb dec 4 1 100meg
.end
