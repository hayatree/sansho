Base current noise with variable RBX
* Provenance: original Sansho R15 circuit.
* sweep: rbx 0 500 2k
.param probe=0
Vc c 0 2
Vb b 0 .70 ac 1
Hread out 0 Vb 1k
Rload out 0 1k
Q1 c b 0 dev
.model dev npn(level=4 is=1e-16 ibei=1e-18 kfn=0 rbx={probe})
.noise v(out) Vb dec 4 1 10meg
.end
