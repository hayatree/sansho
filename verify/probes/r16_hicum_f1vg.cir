Temperature-dependent gap in the saturation multiplier
* Provenance: original Sansho R16 circuit.
* sweep: f1vg -.00015 -.000102377 -.00005
.param probe=-.00015
Vc c 0 1
Vb b 0 .72
Q1 c b 0 0 dev
.model dev npn(level=8 f1vg={probe})
.dc temp -30 120 10
.save i(Vc) i(Vb)
.end
