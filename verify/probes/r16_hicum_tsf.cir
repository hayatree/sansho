Charge storage of the substrate transistor
* Provenance: original Sansho R16 circuit.
* sweep: tsf 0 1n 20n
.param probe=0
Vc c 0 .15 ac 1
Vb b 0 .76
Vs s 0 -.2
Q1 c b 0 s dev
.model dev npn(level=8 tsf={probe} itss=1e-15)
.ac dec 4 100k 10G
.save i(Vs) i(Vb) i(Vc)
.end
