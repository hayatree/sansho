Carrier barrier at low collector bias
* Provenance: original Sansho R16 circuit.
* sweep: barrier 0 1m 5m
.param probe=0
Vc c 0 1
Vb b 0 .79
Q1 c b 0 0 dev
.model dev npn(level=8 icbar={probe} vcbar=.2 acbar=.1)
.dc Vc -.05 2 .025
.save i(Vc) i(Vb)
.end
