Depletion transition over back-gate bias varying cdsbs
* Provenance: original Sansho R17 circuit with synthetic parameters.
* sweep: cdsbs .0001 .001 .005
.param probe=.0001
Vd d 0 0.95
Vg g 0 .8
Ve e 0 0
M1 d g 0 e dev l=.48u w=2.4u
.model dev nmos(level=10 version=4.4 tox=4.6n tsi=30n tbox=105n nch=1.1e17 k1=.42 vth0=.48 u0=.047 soimod=2 fdmod=1 dvbd0=.03 dvbd1=.2 cdsbs={probe})
.dc Ve -1.5 1.5 .15
.save i(Vd)
.end
