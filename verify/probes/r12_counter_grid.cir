Fourth counter clock, original and refined analog grids
* Provenance: original Sansho two-bit counter with internal observations.
* sweep: 0.2n
.param probe=0.2n
Vclk in 0 PULSE(0 1 4n {probe} 0.2n 4n 10n)
Aclk [in] [clk] adc
Ap high pull
Abit0 high clk NULL NULL q0 carry toggle
Abit1 qb1 carry NULL NULL q1 qb1 flip
Aout [q0 q1] [lo hi] dac
R0 lo 0 10k
R1 hi 0 10k
.model adc adc_bridge(in_low=0.5 in_high=0.5 rise_delay=0.1n fall_delay=0.1n)
.model pull d_pullup
.model toggle d_tff(ic=0 clk_delay=0.3n rise_delay=0.1n fall_delay=0.1n)
.model flip d_dff(ic=0 clk_delay=0.3n rise_delay=0.1n fall_delay=0.1n)
.model dac dac_bridge(out_low=0 out_high=1 t_rise=0.2n t_fall=0.2n)
.control
tran 0.5n 50n
eprint clk
eprint q0
eprint carry
eprint q1
print v(in) v(lo) v(hi)
tran 0.5n 50n 0 0.02n
eprint clk
eprint q0
eprint carry
eprint q1
quit
.endc
.end
