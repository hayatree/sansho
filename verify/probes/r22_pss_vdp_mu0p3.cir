Van der Pol pair, mu=0.3
* Provenance: original Sansho oscillator probe for R22.
* sansho-verify: pending-reference
* sansho-verify: pss-ng v(out)
Cx out 0 1m ic=1
Cy y 0 1m
Bx 0 out I={v(y)}
By 0 y I={0.3*(1-v(out)*v(out))*v(y)-v(out)}
.ic v(out)=1 v(y)=0
.pss 155 60m out 64 4 40 0.003 uic
.end
