Substrate impedance around the RSU and CSU pole
* Provenance: original Sansho R16 circuit.
* sweep: csu 0 5p 50p
.param probe=0
Vc c 0 .15 ac 1
Vb b 0 .76
Vs s 0 -.2
Q1 c b 0 s dev
.model dev npn(level=8 csu={probe} rsu=800 cjs0=2p cscp0=.5p)
.ac dec 4 100k 10G
.save i(Vs) i(Vb) i(Vc)
.end
