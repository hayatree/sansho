Band gap dependence of forward diffusion transport
* Provenance: original Sansho R16 circuit.
* sweep: gap 1.08 1.17 1.22
.param probe=1.08
Vc c 0 1
Vb b 0 .72
Q1 c b 0 0 dev
.model dev npn(level=8 vgb={probe})
.dc temp -30 120 10
.save i(Vc) i(Vb)
.end
