Intrinsic base flicker amplitude and frequency slope
* Provenance: original Sansho R16 circuit.
* sweep: kf 0 1e-14 1e-12
.param probe=0
Vc c 0 1
Vb b 0 .76 ac 1
Hread out 0 Vb 1k
Rload out 0 1k
Q1 c b 0 0 dev
.model dev npn(level=8 kf={probe} af=1.3)
.noise v(out) Vb dec 4 1 100meg
.end
