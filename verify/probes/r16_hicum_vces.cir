Residual collector voltage shifts the storage knee
* Provenance: original Sansho R16 circuit.
* sweep: vces .03 .1 .2
.param probe=.03
Vc c 0 1
Vb b 0 .79
Q1 c b 0 0 dev
.model dev npn(level=8 vces={probe} t0=2p thcs=40p)
.dc Vc -.05 2 .025
.save i(Vc) i(Vb)
.end
