SC junction ideality under substrate forward bias
* Provenance: original Sansho R16 circuit.
* sweep: sub_reverse .8 1 1.5
.param probe=.8
Vc c 0 .15
Vb b 0 .76
Vs s 0 .72
Q1 c b 0 s dev
.model dev npn(level=8 iscs=2e-16 msc={probe} itss=1e-16)
.dc Vc .01 .5 .01
.save i(Vs) i(Vb) i(Vc)
.end
