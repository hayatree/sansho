Base current noise with variable BFN
* Provenance: original Sansho R15 circuit.
* sweep: bfn .7 1 1.3
.param probe=.7
Vc c 0 2
Vb b 0 .70 ac 1
Hread out 0 Vb 1k
Rload out 0 1k
Q1 c b 0 dev
.model dev npn(level=4 is=1e-16 ibei=1e-18 kfn=1e-16 afn=1 bfn={probe})
.noise v(out) Vb dec 4 1 10meg
.end
