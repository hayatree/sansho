Compare small-signal collector conductance to a symmetric DC bias difference
* Provenance: original Sansho R16b black-box experiment.
* sweep: gm_tangent .64 .76 .8
.param probe=.64
Vb b 0 {probe} ac 1
Vc c 0 1
Q0 c b 0 0 n
Vhi bh 0 {probe+1u}
Vlo bl 0 {probe-1u}
Vch ch 0 1
Vcl cl 0 1
Qh ch bh 0 0 n
Ql cl bl 0 0 n
.model n npn(level=8)
.op
.ac lin 1 1 1
.save i(Vc) i(Vch) i(Vcl) i(Vb)
.end
