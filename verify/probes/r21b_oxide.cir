Accumulated MOS capacitor with omitted and explicit oxide permittivity
* Provenance: original Sansho fixture, ngspice 44 manual chapter 26.
* sweep: oxide_top -0.01 -0.02 -0.04
.param probe=-0.01
Vomitted omitted 0 dc -0.6 ac 1
Domitted omitted 0 momitted
.model momitted numd level=2
+ options capacitor defw=10u
+ x.mesh loc=0 n=1
+ x.mesh loc=2 n=3
+ y.mesh loc={probe} n=1
+ y.mesh loc=0 n=3
+ y.mesh width=0.8 h.start=0.002 h.max=0.05 ratio=1.35
+ material num=1 silicon
+ material num=2 oxide
+ domain num=1 mat=1 y.l=0
+ domain num=2 mat=2 y.h=0
+ electrode num=1 iy.h=1
+ electrode num=2 y.l=0.8
+ contact num=1 workf=5.29
+ doping uniform p.type conc=1e17 domains=1
+ method ac.analysis=direct
+ end
Vsio sio 0 dc -0.6 ac 1
Dsio sio 0 msio
.model msio numd level=2
+ options capacitor defw=10u
+ x.mesh loc=0 n=1
+ x.mesh loc=2 n=3
+ y.mesh loc={probe} n=1
+ y.mesh loc=0 n=3
+ y.mesh width=0.8 h.start=0.002 h.max=0.05 ratio=1.35
+ material num=1 silicon
+ material num=2 oxide permittivity=3.45313325e-13
+ domain num=1 mat=1 y.l=0
+ domain num=2 mat=2 y.h=0
+ electrode num=1 iy.h=1
+ electrode num=2 y.l=0.8
+ contact num=1 workf=5.29
+ doping uniform p.type conc=1e17 domains=1
+ method ac.analysis=direct
+ end
Vdouble double 0 dc -0.6 ac 1
Ddouble double 0 mdouble
.model mdouble numd level=2
+ options capacitor defw=10u
+ x.mesh loc=0 n=1
+ x.mesh loc=2 n=3
+ y.mesh loc={probe} n=1
+ y.mesh loc=0 n=3
+ y.mesh width=0.8 h.start=0.002 h.max=0.05 ratio=1.35
+ material num=1 silicon
+ material num=2 oxide permittivity=6.9062665e-13
+ domain num=1 mat=1 y.l=0
+ domain num=2 mat=2 y.h=0
+ electrode num=1 iy.h=1
+ electrode num=2 y.l=0.8
+ contact num=1 workf=5.29
+ doping uniform p.type conc=1e17 domains=1
+ method ac.analysis=direct
+ end
.ac lin 1 1meg 1meg
.save i(vomitted) i(vsio) i(vdouble)
.end
