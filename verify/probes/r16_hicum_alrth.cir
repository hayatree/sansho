Thermal resistance referenced to nonnominal ambient
* Provenance: original Sansho R16 circuit.
* sweep: alrth -.005 0 .005
.param probe=-.005
Vc c 0 1.5
Vb b 0 pulse(.58 .78 1u 100n 100n 20u 50u)
.options temp=65
Q1 c b 0 0 tj dev
.model dev npn(level=8 flsh=2 rth=200 cth=10n alrth={probe})
.tran .25u 45u
.save v(tj) i(Vc) i(Vb)
.end
