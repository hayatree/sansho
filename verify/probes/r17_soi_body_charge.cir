Body admittance near the depletion-to-inversion transition
* Provenance: original Sansho R17 circuit with synthetic parameters.
* sweep: body_charge .22 .48 .75
.param probe=.22
Vd d 0 0.95
Vg g 0 {probe}
Ve e 0 0
Vb b 0 .08 ac 1
M1 d g 0 e b dev l=.48u w=2.4u
.model dev nmos(level=10 version=4.4 tox=4.6n tsi=75n tbox=105n nch=1.1e17 k1=.55 vth0=.48 u0=.047 capmod=2)
.ac dec 5 10k 100G
.save i(Vg) i(Vd) i(Ve) i(Vb)
.end
