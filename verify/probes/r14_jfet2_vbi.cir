JFET2 VBI capacitance at unequal end biases
* Provenance: original Sansho R14 circuit.
* sweep: vbi .7 1 1.3
.param probe=.7
Vg g 0 .45 ac 1
Vd d 0 1.8
Vs s 0 0
J1 d g s core
.model core njf(level=2 cgs=3p cgd=1p fc=.5 vbi={probe} is=1e-18)
.ac dec 5 1meg 100meg
.save i(Vg) i(Vd) i(Vs)
.end
