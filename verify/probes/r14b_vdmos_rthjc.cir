Clamped junction response with finite package thermal resistance
* Provenance: original Sansho R14b circuit.
* sweep: rthjc 1 5 20
.param probe=1
Vd d 0 1
Vg g 0 6
Vj tj 0 60
Vc tc 0 27
M1 d g 0 tj tc pw thermal
.model pw vdmos(vto=1 kp=3 rthjc={probe} mu=0 rd=.24 rq=.6 vq=1 texp0=3)
.dc Vd .2 3 .1
.save i(Vd)
.end
