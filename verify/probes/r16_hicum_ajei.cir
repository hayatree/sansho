Forward junction capacitance plateau
* Provenance: original Sansho R16 circuit.
* sweep: ajei 1.5 2.5 5
.param probe=1.5
Vc c 0 1
Vb b 0 .76 ac 1
Q1 c b 0 0 dev
.model dev npn(level=8 cjei0=1p vdei=.72 ajei={probe})
.ac dec 4 1meg 100G
.save i(Vc) i(Vb)
.end
