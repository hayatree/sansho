Junction breakdown versus IBV
* Provenance: original Sansho black-box experiment for ngspice 44.2.
* sweep: 10f 1p 1n 10u 1m
.param probe=1m
Vbias d 0 0
D1 d 0 dut area=2 pj=10u
.model dut d(is=1e-14 n=1 bv=3 ibv={probe} nbv=1.2
+ jsw=1e-10 isr=5p nr=1.8 ikf=1m)
.options temp=27 gmin=1e-18 abstol=1e-18 reltol=1e-7
.dc Vbias -3.04 -1.8 0.002
.save i(Vbias)
.end
