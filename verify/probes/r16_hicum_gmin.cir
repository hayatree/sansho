Junction shunt current below turn-on at scaled area
* Provenance: original Sansho R16 circuit.
* sweep: gmin 1e-14 1e-12 1e-10
.param probe=1e-14
Vc c 0 1
Vb b 0 .79
.options gmin={probe}
Q1 c b 0 0 dev area=3 m=2
.model dev npn(level=8 c10=0 ibeis=0 ibcis=0)
.dc Vc -.05 2 .025
.save i(Vc) i(Vb)
.end
