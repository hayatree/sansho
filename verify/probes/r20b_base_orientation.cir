NBJT orientation dependence
* Provenance: original Sansho R20b black-box experiment.
* sweep: vce 0.2 0.45 0.65
* Subtract I(Vbr) from minus I(Vb) with consistent source signs to separate the two base currents.
.param probe=0.2
Vc c 0 {probe}
Vb b 0 dc 0.48 ac 1
Qvertical c b 0 crystal
Vcr cr 0 {probe}
Vbr b br 0
Qreverse 0 br cr crystal
.model crystal nbjt level=1
+ options defa=1e-10 bipolar base.depth=1.2 base.length=0.7
+ x.mesh location=0 number=1
+ x.mesh location=2.4 number=62
+ domain number=1 material=1
+ material number=1 silicon tn=2n tp=3n
+ doping uniform n.type conc=1e+16
+ doping uniform p.type conc=8e16 x.low=1.0 x.high=1.4
+ doping uniform n.type conc=2e18 x.low=1.4
+ models srh concmob
+ end
.options itl1=150 itl2=100
.dc Vb 0.2 0.62 0.02
.save i(vb) i(vc) i(vbr) i(vcr)
.end
