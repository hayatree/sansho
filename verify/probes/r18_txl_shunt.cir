Shunt-dominated and distortionless propagation
* Provenance: original Sansho R18 circuit.
* sweep: leakage 1m 4m 16m
* reference-error: 4m | Error: Gaussian elimination fails during setup of TXL
.param probe=1m
Vin src 0 dc 0 ac 1 pulse(0 1 1n .1n .1n 45n 100n)
Rs src near 50
Y1 near 0 far 0 wire
.model wire txl(r=10 l=250n g={probe} c=100p length=1)
Rl far 0 50
.tran .04n 22n
.save v(near) v(far) i(Vin)
.end
