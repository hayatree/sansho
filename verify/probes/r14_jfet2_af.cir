JFET2 AF noise versus frequency
* Provenance: original Sansho R14 circuit.
* sweep: af .6 1 1.4
.param probe=.6
Vg g 0 -.5 ac 1
Vd d 0 2
Hsense out 0 Vd 1k
J1 d g 0 core
.model core njf(level=2 beta=.4m af={probe} kf=1e-20)
.noise v(out) Vg dec 4 1 100meg
.end
