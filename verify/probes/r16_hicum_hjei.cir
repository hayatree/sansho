BE depletion charge weighting at fixed junction doping
* Provenance: original Sansho R16 circuit.
* sweep: hjei 0 1 2
.param probe=0
Vc c 0 1
Vb b 0 .72
Q1 c b 0 0 dev
.model dev npn(level=8 hjei={probe} cjei0=15f)
.dc Vb .4 .88 .02
.save i(Vc) i(Vb)
.end
