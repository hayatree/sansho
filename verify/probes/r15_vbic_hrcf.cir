Epitaxial collector HRCF across the output knee
* Provenance: original Sansho R15 circuit.
* sweep: hrcf .2 1 8
.param probe=.2
Vc c 0 1
Ib 0 b 25u
Q1 c b 0 dev
.model dev npn(level=4 is=1e-16 ibei=1e-18 rci=16 gamm=2e-10 vo=.8 rcx=1.5 rbi=18 rbx=4 re=.4 vef=65 hrcf={probe})
.dc Vc .02 2 .03 Ib 10u 90u 20u
.save v(b) i(Vc)
.end
