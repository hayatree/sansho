Instance depletion selector overrides the model card
* Provenance: original Sansho R17 circuit with synthetic parameters.
* sweep: instance_mode 0 1 2 3
.param probe=0
Vd d 0 0.95
Vg g 0 .8
Ve e 0 0
M1 d g 0 e dev l=.48u w=2.4u soimod={probe}
.model dev nmos(level=10 version=4.4 tox=4.6n tsi=44n tbox=105n nch=1.1e17 k1=.42 vth0=.48 u0=.047 soimod=2)
.dc Ve -1.5 1.5 .1
.save i(Vd)
.end
