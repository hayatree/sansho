Substrate collection shot spectrum
* Provenance: original Sansho R16 circuit.
* sweep: substrate_shot 0 1e-16 4e-16
.param probe=0
Vc c 0 .1
Vb b 0 .76
Hread out 0 Vs 1k
Rload out 0 1k
Vs s 0 -.2 ac 1
Q1 c b 0 s dev
.model dev npn(level=8 itss={probe} iscs=1e-17 cjs0=1p)
.noise v(out) Vs dec 4 1 100meg
.end
