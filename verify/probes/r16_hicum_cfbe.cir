Flicker site on opposite sides of a base resistance
* Provenance: original Sansho R16 circuit.
* sweep: cfbe 0 1
.param probe=0
Vc c 0 1
Vb b 0 .76 ac 1
Hread out 0 Vb 1k
Rload out 0 1k
Q1 c b 0 0 dev
.model dev npn(level=8 cfbe={probe} kf=1e-12 ibeps=3e-18 rbi0=400 af=1.3)
.noise v(out) Vb dec 4 1 100meg
.end
