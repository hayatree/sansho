Film history after a five-component IC tuple
* Provenance: original Sansho R17 circuit with synthetic parameters.
* sweep: ic_body -.25 0 .25
.param probe=-.25
Vd d 0 .6
Vg g 0 .85
Ve e 0 0
Vp p 0 0
M1 d g 0 e p dev l=.48u w=2.4u ic=.6,.85,{probe},0,0
.model dev nmos(level=10 version=4.4 tox=4.6n tsi=75n tbox=105n nch=1.1e17 k1=.42 vth0=.48 u0=.047 rbsh=100meg)
.options method=gear itl4=60
.tran 5n 1u uic
.save i(Vd) @m1[vbs]
.end
