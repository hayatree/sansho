Independent P drive with the sixth pin resistively loaded
* Provenance: original Sansho R17 circuit with synthetic parameters.
* sweep: zero_contact 0 10 100
.param probe=0
Vd d 0 0.95
Vg g 0 .8
Ve e 0 0
Vp p 0 .2
Rfilm b 0 3k
M1 d g 0 e p b dev l=.48u w=2.4u
.model dev nmos(level=10 version=4.4 tox=4.6n tsi=75n tbox=105n nch=1.1e17 k1=.42 vth0=.48 u0=.047 rbsh={probe})
.dc Vp -.15 .55 .05
.save i(Vp) v(b) i(Vd)
.end
