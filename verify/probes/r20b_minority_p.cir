One-sided injection with concentration mobility
* Provenance: original Sansho R20b black-box experiment.
* sweep: density 1e15 1e16 7e16 3e17 1e18
* The lightly doped side sets minority diffusion. The other branch fixes its bulk mobility.
.param probe=1e15
Vdrive drive 0 0
Vref drive node_ref 0
Dref node_ref 0 mref
.model mref numd level=1
+ options diode defa=1e-10
+ x.mesh loc=0 n=1
+ x.mesh loc=2.4 n=62
+ domain num=1 material=1
+ material num=1 silicon
+ doping uniform p.type conc=3e19 x.high=1.2
+ doping uniform n.type conc={probe} x.low=1.2
+ end
Vtest drive node_test 0
Dtest node_test 0 mtest
.model mtest numd level=1
+ options diode defa=1e-10
+ x.mesh loc=0 n=1
+ x.mesh loc=2.4 n=62
+ domain num=1 material=1
+ material num=1 silicon
+ doping uniform p.type conc=3e19 x.high=1.2
+ doping uniform n.type conc={probe} x.low=1.2
+ models concmob
+ end
.options itl1=200 itl2=120 reltol=1e-5 abstol=1e-15
.dc Vdrive 0.30 0.54 0.03
.save i(vref) i(vtest)
.end
