BSIM2 PBSW diffusion geometry and body admittance
* Provenance: original Sansho R14 circuit.
* sweep: pbsw .55 .8 1
.param probe=.55
Vd d 0 1.5 ac 1
Vg g 0 -1
Vb b 0 -.25
M1 d g 0 b dev pd=10u w=4u l=1.2u
.model dev nmos(level=5 phi=.7 js=1e-6 cj=.002 cjsw=5e-10 vfb=-.52 k1=.55 tox=.025 mu0=470 ua0=.12 ub0=.02 u10=.1 eta0=.012 vdd=3 temp=27 n0=1.45 xpart=0 k2=.025 pbsw={probe})
.ac dec 6 1k 1g
.save i(Vd) i(Vb)
.end
