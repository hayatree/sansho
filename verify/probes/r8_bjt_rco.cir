Loaded bipolar quasi-saturation versus epi resistance
* Provenance: original Sansho R8b black-box experiment.
* sweep: 3 20 50
.param probe=50
Vcc rail 0 5
Rc rail c 100
Vdrive in 0 0
Rb in b 250
Q1 c b 0 0 sw area=1 areab=2 areac=3
.model sw npn(is=1e-15 bf=150 br=3 rb=1 rc=0.5 re=0.2
+ rco={probe} gamma=1e-11 qco=0 vo=2 tf=0.5n tr=8n cje=2p cjc=4p cjs=3p)
.dc Vdrive 0 3 0.1
.save v(c) v(b) i(vcc) i(vdrive)
.end
