One-sided SRH minority lifetime
* Provenance: original Sansho R20b black-box experiment.
* sweep: tau 1e-9 1e-7 1e-6 1e-5
* Compare explicit and omitted lifetimes over low and moderate injection.
.param probe=1e-9
Vdrive drive 0 0
Voff drive node_off 0
Doff node_off 0 moff
.model moff numd level=1
+ options diode defa=1e-10
+ x.mesh loc=0 n=1
+ x.mesh loc=39.5 n=25
+ x.mesh loc=40.5 n=126
+ x.mesh loc=80 n=150
+ domain num=1 material=1
+ material num=1 silicon
+ doping uniform p.type conc=1e18 x.high=40
+ doping uniform n.type conc=1e16 x.low=40
+ end
Vdefault drive node_default 0
Ddefault node_default 0 mdefault
.model mdefault numd level=1
+ options diode defa=1e-10
+ x.mesh loc=0 n=1
+ x.mesh loc=39.5 n=25
+ x.mesh loc=40.5 n=126
+ x.mesh loc=80 n=150
+ domain num=1 material=1
+ material num=1 silicon
+ doping uniform p.type conc=1e18 x.high=40
+ doping uniform n.type conc=1e16 x.low=40
+ models srh
+ end
Vtest drive node_test 0
Dtest node_test 0 mtest
.model mtest numd level=1
+ options diode defa=1e-10
+ x.mesh loc=0 n=1
+ x.mesh loc=39.5 n=25
+ x.mesh loc=40.5 n=126
+ x.mesh loc=80 n=150
+ domain num=1 material=1
+ material num=1 silicon tp={probe}
+ doping uniform p.type conc=1e18 x.high=40
+ doping uniform n.type conc=1e16 x.low=40
+ models srh
+ end
.options itl1=200 itl2=120 reltol=1e-5 abstol=1e-15
.dc Vdrive 0.30 0.54 0.03
.save i(voff) i(vdefault) i(vtest)
.end
