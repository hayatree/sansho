Mixed analysis plot order, reverse
* Provenance: original Sansho R22e black-box plot-order probe.
Vdrive in 0 dc 0.4 ac 1 distof1 1m portnum=1 z0=50 sin(0.4 0.2 1k)
Rdrive in sense 1k
Rfeed sense out 1k
Clead sense out 10n
Rload out 0 2k
Ddet out 0 dj
.model dj d(is=1e-14)
.ac lin 2 700 2.6k
.dc Vdrive 0.3 0.5 0.1
.sens v(out)
.disto lin 3 1k 2k
.op
.noise v(out) Vdrive lin 3 1k 2k
.pz sense 0 out 0 vol pz
.tf v(out) Vdrive
.sp lin 3 1k 2k
.tran 10u 4m
.meas tran peak max v(out)
.four 1k v(out)
.end
