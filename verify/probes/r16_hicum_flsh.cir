Main versus total heat dissipation with an external thermal path
* Provenance: original Sansho R16 circuit.
* sweep: flsh 0 1 2
.param probe=0
Vc c 0 1.5
Vb b 0 pulse(.58 .78 1u 100n 100n 20u 50u)
Renv tj 0 2k
Q1 c b 0 0 tj dev
.model dev npn(level=8 flsh={probe} rth=400 cth=30n re=5 rbx=25)
.tran .25u 45u
.save v(tj) i(Vc) i(Vb)
.end
