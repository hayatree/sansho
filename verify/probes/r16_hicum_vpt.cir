Collector reach-through contribution to critical current
* Provenance: original Sansho R16 circuit.
* sweep: vpt 1 5 100
.param probe=1
Vc c 0 1
Vb b 0 .79
Q1 c b 0 0 dev
.model dev npn(level=8 vpt={probe} tef0=12p)
.dc Vc -.05 2 .025
.save i(Vc) i(Vb)
.end
