Area scaling of flicker with noninteger current exponent
* Provenance: original Sansho R16 circuit.
* sweep: noise_area 1 2 4
.param probe=1
Vc c 0 1
Vb b 0 .76 ac 1
Hread out 0 Vb 1k
Rload out 0 1k
Q1 c b 0 0 dev area={probe}
.model dev npn(level=8 kf=1e-12 af=1.3)
.noise v(out) Vb dec 4 1 100meg
.end
