Recover depletion displacement from the AHJEI integral as RHJEI varies
* Provenance: original Sansho R16b black-box experiment.
* sweep: heterojunction .5 1 2
.param probe=1
Vc c 0 1
Vb b 0 .72
Q1 c b 0 0 n
.model n npn(level=8 cjei0=10f ahjei=4 dvgbe=.72 rhjei={probe})
.dc Vb .4 .88 .01
.save i(Vc) i(Vb)
.end
