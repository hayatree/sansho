Gate end cells with touching and recessed ohmic side contacts
* Provenance: original Sansho fixture, ngspice 44 manual chapter 26.
* sweep: ohmic_start 0 0.002 0.008
.param probe=0
Vgfull gfull 0 dc 0.9 ac 1
Vdfull dfull 0 0.05
Mfull dfull gfull 0 0 mfull
.model mfull numos
+ options mosfet defw=5u
+ x.mesh loc=0 n=1
+ x.mesh loc=0.4 n=3
+ x.mesh loc=2.4 n=13
+ x.mesh loc=2.8 n=15
+ y.mesh loc=-0.02 n=1
+ y.mesh loc=0 n=2
+ y.mesh loc=0.002 n=3
+ y.mesh loc=0.008 n=4
+ y.mesh loc=0.022 n=5
+ y.mesh loc=0.052 n=6
+ y.mesh loc=0.12 n=7
+ y.mesh loc=0.28 n=8
+ y.mesh loc=0.65 n=10
+ region num=1 mat=1 y.l=0
+ region num=2 mat=2 y.h=0
+ material num=1 silicon
+ material num=2 oxide
+ electrode num=1 ix.l=15 y.l={probe} iy.h=7
+ electrode num=2 iy.h=1
+ electrode num=3 ix.h=1 y.l={probe} iy.h=7
+ electrode num=4 iy.l=10
+ contact num=2 workf=4.5
+ doping uniform p.type conc=1e16 domains=1
+ doping uniform n.type conc=1e18 x.h=0.39 y.l=0 y.h=0.12 domains=1
+ doping uniform n.type conc=1e18 x.l=2.41 y.l=0 y.h=0.12 domains=1
+ method ac.analysis=direct
+ end
Vginset ginset 0 dc 0.9 ac 1
Vdinset dinset 0 0.05
Minset dinset ginset 0 0 minset
.model minset numos
+ options mosfet defw=5u
+ x.mesh loc=0 n=1
+ x.mesh loc=0.4 n=3
+ x.mesh loc=2.4 n=13
+ x.mesh loc=2.8 n=15
+ y.mesh loc=-0.02 n=1
+ y.mesh loc=0 n=2
+ y.mesh loc=0.002 n=3
+ y.mesh loc=0.008 n=4
+ y.mesh loc=0.022 n=5
+ y.mesh loc=0.052 n=6
+ y.mesh loc=0.12 n=7
+ y.mesh loc=0.28 n=8
+ y.mesh loc=0.65 n=10
+ region num=1 mat=1 y.l=0
+ region num=2 mat=2 y.h=0 ix.l=2 ix.h=14
+ material num=1 silicon
+ material num=2 oxide
+ electrode num=1 ix.l=15 y.l={probe} iy.h=7
+ electrode num=2 iy.h=1
+ electrode num=3 ix.h=1 y.l={probe} iy.h=7
+ electrode num=4 iy.l=10
+ contact num=2 workf=4.5
+ doping uniform p.type conc=1e16 domains=1
+ doping uniform n.type conc=1e18 x.h=0.39 y.l=0 y.h=0.12 domains=1
+ doping uniform n.type conc=1e18 x.l=2.41 y.l=0 y.h=0.12 domains=1
+ method ac.analysis=direct
+ end
.ac dec 1 1k 1meg
.save i(vgfull) i(vdfull) i(vginset) i(vdinset)
.end
