JFET2 N bias dependence
* Provenance: original Sansho R14 circuit.
* sweep: n 1 1.3 1.7
.param probe=1
Vd d 0 1.8
Vg g 0 -.6 ac 1
J1 d g 0 dev
.model dev njf(level=2 beta=0.7m vto=-1.6 cgs=4p cgd=1p n={probe})
.dc Vg -3 .35 .025
.save i(Vd) i(Vg)
.end
