Diffusion charge modulation of base conductance
* Provenance: original Sansho R16 circuit.
* sweep: fqi 0 .5 1
.param probe=0
Vc c 0 1
Vb b 0 .72
Q1 c b 0 0 dev
.model dev npn(level=8 rbi0=500 fqi={probe} t0=20p)
.dc Vb .4 .88 .02
.save i(Vc) i(Vb)
.end
