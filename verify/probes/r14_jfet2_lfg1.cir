JFET2 LFG1 bias dependence
* Provenance: original Sansho R14 circuit.
* sweep: lfg1 0 .012 .03
.param probe=0
Vd d 0 1.8
Vg g 0 -.6 ac 1
J1 d g 0 dev
.model dev njf(level=2 beta=0.7m vto=-1.6 cgs=4p cgd=1p lfgam=.02 lfg1={probe})
.dc Vg -2.3 .0 .05 Vd .12 2.12 1
.save i(Vd) i(Vg)
.end
