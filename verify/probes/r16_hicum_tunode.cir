Tunnelling site with a measurable series base drop
* Provenance: original Sansho R16 circuit.
* sweep: tunode 0 1
.param probe=0
Vc c 0 .05
Vb b 0 0
Q1 c b 0 0 dev
.model dev npn(level=8 tunode={probe} ibets=10u abet=3 rbi0=2k)
.dc Vb -4 -.2 .1
.save i(Vb)
.end
