Lateral transport with reversed drain and unequal emitter densities
* Provenance: original Sansho R17 circuit with synthetic parameters.
* sweep: bjt_reverse .002 .02 .2
.param probe=.002
Vd d 0 -.18
Vg g 0 .15
Ve e 0 0
Vb b 0 .1
M1 d g 0 e b dev l=.48u w=2.4u
.model dev nmos(level=10 version=4.4 tox=4.6n tsi=75n tbox=105n nch=1.1e17 k1=.42 vth0=.48 u0=.047 isbjt=.02 idbjt={probe})
.dc Vb -.2 .4 .025
.save i(Vb) i(Vd)
.end
