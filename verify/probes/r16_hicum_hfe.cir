Weight of excess emitter charge in GICCR
* Provenance: original Sansho R16 circuit.
* sweep: hfe 0 .5 2
.param probe=0
Vc c 0 1
Vb b 0 .72
Q1 c b 0 0 dev
.model dev npn(level=8 hfe={probe} tef0=15p)
.dc Vb .4 .88 .02
.save i(Vc) i(Vb)
.end
