Sidewall junction capacitance at three silicon film thicknesses
* Provenance: original Sansho R17 circuit with synthetic parameters.
* sweep: film_normalization 25n 65n 120n
.param probe=25n
Vd d 0 0.95
Vg g 0 0
Ve e 0 0
Vb b 0 -.1 ac 1
M1 d g 0 e b dev l=.48u w=2.4u
.model dev nmos(level=10 version=4.4 tox=4.6n tsi={probe} tbox=105n nch=1.1e17 k1=.42 vth0=.48 u0=.047 cjswg=2n)
.ac dec 5 10k 100G
.save i(Vg) i(Vd) i(Ve) i(Vb)
.end
