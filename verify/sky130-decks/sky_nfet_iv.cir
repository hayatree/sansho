* SKY130 nfet_01v8 Id-Vg in two bins at low and high drain bias
* Requires the open_pdks/volare SKY130 build under va-models/volare-sky130 (sky130A).
* Provenance: original SKY130 test circuit.
.lib "../../va-models/volare-sky130/sky130A/libs.tech/ngspice/sky130.lib.spice" tt
vd d 0 0.05
vd2 d2 0 1.8
vg g 0 0
xm1 d g 0 0 sky130_fd_pr__nfet_01v8 w=1 l=0.15 nf=1
xm2 d2 g 0 0 sky130_fd_pr__nfet_01v8 w=1 l=0.15 nf=1
xm3 d2 g 0 0 sky130_fd_pr__nfet_01v8 w=5 l=1 nf=1
.dc vg 0 1.8 10m
.end
