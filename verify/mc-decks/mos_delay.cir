MOS1 inverter falling propagation delay
* Provenance: original inverter and process distribution.
.param threshold=agauss(0.48,0.06,3) mobility=gauss(100u,0.15,3)
.model nch nmos level=1 vto={threshold} kp={mobility} lambda=0.02
.model pch pmos level=1 vto={-threshold} kp={mobility/2} lambda=0.02
Vrail vdd 0 1.8
Vedge in 0 pulse(0 1.8 100p 10p 10p 2n 5n)
Mpull out in 0 0 nch w=2u l=1u
Mup out in vdd vdd pch w=4u l=1u
Cload out 0 50f
.tran 3p 1n
.meas tran delay trig v(in) val=0.9 rise=1 targ v(out) val=0.9 fall=1
.end
