Statistical reference driver for mos_delay
* Provenance: original black-box control loop. Start in verify/mc-decks.
.control
setseed 7381
set numdgt=16
echo delay > ../out/mos_delay.mc.txt
repeat 200
  source mos_delay.cir
  run
  meas tran delay trig v(in) val=0.9 rise=1 targ v(out) val=0.9 fall=1
  echo $&delay >> ../out/mos_delay.mc.txt
  destroy $curplot
  remcirc
end
quit
.endc
.end
