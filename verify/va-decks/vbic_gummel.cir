* HBT collector and base Gummel currents
* Requires va-models/ihp/vbic_1p3/vbic_1p3.va with adjacent includes,
* and ngspice-models/cornerHBT.lib with sg13g2_hbt_mod.lib.
* ngspice uses its native level-9 Q device. spx uses five-terminal VBIC 1.3.
* The ngspice voltage-limit warnings are advisory.
* .save selects reference signals. spx records all unknowns.
* Provenance: original SG13G2 test circuit.
.lib "../../va-models/ihp/ngspice-models/cornerHBT.lib" hbt_typ
.hdl "vbic_5t.va"
Vc c 0 1
Vb b 0 0.4
Xq c b 0 0 npn13G2
.dc Vb 0.4 0.85 5m
.save i(vc) i(vb)
.end
