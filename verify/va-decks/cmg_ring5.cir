* BSIM-CMG five-stage FinFET ring oscillator
* Requires va-models/bsimcmg/bsimcmg.va (BSIM-CMG 111.2.1) with its adjacent includes.
* Provenance: original BSIM-CMG test circuit; generic parameter values chosen for Sansho.
.hdl "../../va-models/bsimcmg/bsimcmg.va"
.model nfin bsimcmg_va type=1 geomod=1 bulkmod=1 rdsmod=0 tfin=8n hfin=40n fpitch=40n eot=1.0n phig=4.35 nbody=5e23 u0=0.035 vsat=1.0e5 cdsc=5e-3 dvt0=0.1 dvt1=0.5 eta0=0.05 rshs=50 cgso=1e-10 cgdo=1e-10 cjs=5e-4
.model pfin bsimcmg_va type=-1 geomod=1 bulkmod=1 rdsmod=0 tfin=8n hfin=40n fpitch=40n eot=1.0n phig=4.85 nbody=5e23 u0=0.012 vsat=0.8e5 cdsc=5e-3 dvt0=0.1 dvt1=0.5 eta0=0.05 rshs=60 cgso=1e-10 cgdo=1e-10 cjs=5e-4
.subckt inv in out vdd
np out in vdd vdd 0 pfin l=20n nfin=4
nn out in 0 0 0 nfin l=20n nfin=3
.ends
vdd vdd 0 0.8
x1 a b vdd inv
x2 b c vdd inv
x3 c d vdd inv
x4 d e vdd inv
x5 e a vdd inv
c1 a 0 0.2f
.ic v(a)=0 v(b)=0.8 v(c)=0 v(d)=0.8 v(e)=0
.tran 0.5p 300p
.end
