* BSIM-CMG n-FinFET Id-Vg at low and high drain bias, and a long device
* Requires va-models/bsimcmg/bsimcmg.va (BSIM-CMG 111.2.1) with its adjacent includes.
* Provenance: original BSIM-CMG test circuit; generic parameter values chosen for Sansho.
.hdl "../../va-models/bsimcmg/bsimcmg.va"
.model nfin bsimcmg_va type=1 geomod=1 bulkmod=1 rdsmod=0 tfin=8n hfin=40n fpitch=40n eot=1.0n phig=4.35 nbody=5e23 u0=0.035 vsat=1.0e5 cdsc=5e-3 dvt0=0.1 dvt1=0.5 eta0=0.05 rshs=50 cgso=1e-10 cgdo=1e-10 cjs=5e-4
vd d 0 0.05
vd2 d2 0 0.8
vg g 0 0
n1 d g 0 0 0 nfin l=20n nfin=4
n2 d2 g 0 0 0 nfin l=20n nfin=4
n3 d2 g 0 0 0 nfin l=200n nfin=2
.dc vg 0 0.9 10m
.end
