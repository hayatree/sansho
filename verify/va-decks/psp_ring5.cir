* Five-stage capacitively loaded CMOS ring
* Requires va-models/ihp/psp103/{psp103,psp103_nqs}.va with adjacent includes,
* and ngspice-models/cornerMOSlv.lib with sg13g2_moslv_{mod,parm}.lib.
* .save selects reference signals. spx records all unknowns.
* Provenance: original SG13G2 test circuit.
.lib "../../va-models/ihp/ngspice-models/cornerMOSlv.lib" mos_tt
.hdl "../../va-models/ihp/psp103/psp103.va"
.hdl "../../va-models/ihp/psp103/psp103_nqs.va"
Vdd vdd 0 1.2
.subckt inv in out vdd
Xn out in 0 0 sg13_lv_nmos w=1u l=0.13u
Xp out in vdd vdd sg13_lv_pmos w=2u l=0.13u
Cl out 0 10f
.ends
X0 n4 n0 vdd inv
X1 n0 n1 vdd inv
X2 n1 n2 vdd inv
X3 n2 n3 vdd inv
X4 n3 n4 vdd inv
.ic v(n0)=1.2 v(n1)=0 v(n2)=1.2 v(n3)=0 v(n4)=1.2
.tran 4p 1.2n
.measure tran period trig v(n0) val=0.6 rise=1 targ v(n0) val=0.6 rise=2
.save v(n0)
.end
