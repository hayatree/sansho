* BSIM-CMG FinFET inverter driving a fan-out of four, transient
* Requires va-models/bsimcmg/bsimcmg.va (BSIM-CMG 111.2.1) with its adjacent includes.
* Provenance: original BSIM-CMG test circuit; generic parameter values chosen for Sansho.
.hdl "../../va-models/bsimcmg/bsimcmg.va"
.model nfin bsimcmg_va type=1 geomod=1 bulkmod=1 rdsmod=0 tfin=8n hfin=40n fpitch=40n eot=1.0n phig=4.35 nbody=5e23 u0=0.035 vsat=1.0e5 cdsc=5e-3 dvt0=0.1 dvt1=0.5 eta0=0.05 rshs=50 cgso=1e-10 cgdo=1e-10 cjs=5e-4
.model pfin bsimcmg_va type=-1 geomod=1 bulkmod=1 rdsmod=0 tfin=8n hfin=40n fpitch=40n eot=1.0n phig=4.85 nbody=5e23 u0=0.012 vsat=0.8e5 cdsc=5e-3 dvt0=0.1 dvt1=0.5 eta0=0.05 rshs=60 cgso=1e-10 cgdo=1e-10 cjs=5e-4
vdd vdd 0 0.8
vin in 0 pulse(0 0.8 50p 20p 20p 300p 700p)
np out in vdd vdd 0 pfin l=20n nfin=4
nn out in 0 0 0 nfin l=20n nfin=3
np2 o2 out vdd vdd 0 pfin l=20n nfin=16
nn2 o2 out 0 0 0 nfin l=20n nfin=12
.tran 0.5p 1.4n
.end
