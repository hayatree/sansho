* Common-source small-signal gain
* Requires va-models/ihp/psp103/{psp103,psp103_nqs}.va with adjacent includes,
* and ngspice-models/cornerMOSlv.lib with sg13g2_moslv_{mod,parm}.lib.
* .save selects reference signals. spx records all unknowns.
* Provenance: original SG13G2 test circuit.
.lib "../../va-models/ihp/ngspice-models/cornerMOSlv.lib" mos_tt
.hdl "../../va-models/ihp/psp103/psp103.va"
.hdl "../../va-models/ihp/psp103/psp103_nqs.va"
Vdd vdd 0 1.2
Vg g 0 0.6 ac 1
Rd vdd d 12k
Xd d g 0 0 sg13_lv_nmos w=1u l=0.13u
.ac dec 10 1k 100G
.save v(d)
.end
