BSIM3 temperature sweep with independent channel and junction current sensing
* sansho-verify: known-difference Chapter 9 junction current includes the sidewall term; ngspice 44.2 matches the area-only current
* Provenance: original Sansho circuit and parameter choices from the BSIM3v3.3 parameter list.
.model nch nmos level=8 version=3.3
+ tox=8n xj=0.13u nch=2.1e17 vth0=0.54 k1=0.52 k2=-0.023
+ u0=460 vsat=92000 rdsw=85 pclm=1.15
+ lint=9n wint=15n cgso=170p cgdo=150p cf=65p kt1=-0.18 ute=-1.7 at=28000 ua1=3n js=0.0003 jssw=3e-11 ijth=0.015
Vg g 0 1.24
Vd d 0 1.1
Vj j 0 -0.57
Mc d g 0 0 nch w=1.8u l=0.5u
Mj j j j 0 nch w=1.8u l=0.5u ad=3p as=3p pd=8u ps=8u
.dc temp -25 125 5
.save i(Vd) i(Vj)
.end
