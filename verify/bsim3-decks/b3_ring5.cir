BSIM3 five-stage loaded CMOS ring with staggered initial voltages
* sansho-verify: known-difference follows the CGBO default difference of b3_cap2 (period 3.406 vs 3.417 ns)
* Provenance: original Sansho circuit and parameter choices from the BSIM3v3.3 parameter list.
.model nch nmos level=8 version=3.3
+ tox=8n xj=0.13u nch=2.1e17 vth0=0.54 k1=0.52 k2=-0.023
+ u0=460 vsat=92000 rdsw=85 pclm=1.15
+ lint=9n wint=15n cgso=170p cgdo=150p cf=65p capmod=3
.model pch pmos level=49 version=3.3.0
+ tox=8n xj=0.13u nch=2.1e17 vth0=-0.58 k1=0.52 k2=-0.023
+ u0=185 vsat=76000 rdsw=130 pclm=1.15
+ lint=9n wint=15n cgso=170p cgdo=150p cf=65p capmod=3
Vdd rail 0 1.8
.subckt inv in out rail
Mn out in 0 0 nch w=1.5u l=0.45u ad=0.5p as=0.5p pd=3u ps=3u
Mp out in rail rail pch w=3.4u l=0.45u ad=1p as=1p pd=5u ps=5u
.ends

X1 e a rail inv
X2 a b rail inv
X3 b c rail inv
X4 c d rail inv
X5 d e rail inv
Ca a 0 18f
Cb b 0 18f
Cc c 0 18f
Cd d 0 18f
Ce e 0 18f
.ic v(rail)=1.8 v(a)=1.8 v(b)=0 v(c)=1.8 v(d)=0 v(e)=0
.tran 5p 6n uic
.save v(a) v(c) v(e)
.end
