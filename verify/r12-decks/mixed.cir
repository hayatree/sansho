Comparator and frequency divider with filtered DAC feedback
* Provenance: original Sansho circuit.
Vdrive stim 0 PULSE(-0.5 1.5 4n 2n 2n 4n 12n)
Ecompare diff 0 stim fb 1
Acomp [diff] [clock] adc
Adivide clock q div
Aout [q] [drive] dac
Rf drive fb 1k
Cf fb 0 5p
.model adc adc_bridge(in_low=0 in_high=0 rise_delay=0.2n fall_delay=0.2n)
.model div d_fdiv(div_factor=2 high_cycles=1 i_count=0 rise_delay=0.3n fall_delay=0.3n)
.model dac dac_bridge(out_low=0 out_high=1 t_rise=0.5n t_fall=0.5n)
.tran 0.5n 63n
.save v(drive) v(fb) v(diff)
.print tran v(drive) v(fb) v(diff)
.end
