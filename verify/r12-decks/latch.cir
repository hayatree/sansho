SR latch rejects a short set pulse
* Provenance: original Sansho circuit.
Vset s 0 PWL(0 0 2n 0 2.2n 1 3n 1 3.2n 0 8n 0 8.2n 1 13n 1 13.2n 0)
Vreset r 0 PULSE(0 1 20n 0.2n 0.2n 4n 40n)
Ainput [s r] [ds dr] adc
Afilter ds clean buf
Aenable on pull
Alatch clean dr on NULL NULL q NULL latch
Aout [q] [out] dac
Rload out 0 10k
.model adc adc_bridge(in_low=0.5 in_high=0.5 rise_delay=0 fall_delay=0)
.model buf d_buffer(rise_delay=2n fall_delay=2n)
.model pull d_pullup
.model latch d_srlatch(ic=0 sr_delay=0.1n enable_delay=0.1n rise_delay=0.1n fall_delay=0.1n)
.model dac dac_bridge(out_low=0 out_high=1 t_rise=0.2n t_fall=0.2n)
.tran 0.5n 30n
.save v(out)
.print tran v(out)
.end
