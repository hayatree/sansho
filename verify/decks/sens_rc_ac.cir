Complex parameter sensitivities of an RC low pass
* Provenance: original R2 verification circuit.
* sansho-verify: known-difference ngspice 44 v(r1) AC sensitivity is zero above the first frequency; Sansho matches the analytic derivative and ngspice v(r1_ac)
Vin in 0 dc 0 ac 1
R1 in out 1k
C1 out 0 10n
.sens v(out) ac dec 4 1k 100k
.end
