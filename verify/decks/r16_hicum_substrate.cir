Lateral transistor current flowing into a biased substrate contact
* Provenance: original Sansho R16 circuit.
Vc c 0 .15
Vb b 0 .76
Vs s 0 -.2
Q1 c b 0 s dev
.model dev npn(level=8 itss=2e-16 iscs=1e-16 rsu=40 csu=8p rbx=5 rcx=3)
.dc Vc .01 .5 .01
.save i(Vs) i(Vb) i(Vc)
.end
