Series RLC ring-down from initial conditions (UIC)
C1 a 0 1n
L1 a b 10u
R1 b 0 2
.ic v(a)=1
.tran 1n 2u uic
.end
