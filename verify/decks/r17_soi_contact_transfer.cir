CONTACT SOI transfer characteristic
* Provenance: original Sansho R17 circuit with synthetic parameters.
Vd d 0 0.95
Vg g 0 .8
Ve e 0 0
Vb b 0 .08
M1 d g 0 e b dev l=.48u w=2.4u
.model dev nmos(level=10 version=4.4 tox=4.6n tsi=75n tbox=105n nch=1.1e17 k1=.42 vth0=.48 u0=.047 alpha0=.00012 beta2=.24 vdsatii0=1.08 isdif=.015 isbjt=.001 rbsh=45)
.dc Vg -.2 1.3 .025 Vd .1 1.1 .5
.save i(Vd) i(Vg) i(Vb)
.end
