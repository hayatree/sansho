Device transconductance and output conductance inside a subcircuit
* Provenance: original Sansho R7 circuit.
* verify: atol_v=1e-12
.subckt cell d g
M1 d g 0 0 n1 w=8u l=2u
.model n1 nmos(level=1 vto=0.6 kp=40u lambda=0.015)
.ends
X1 drain gate cell
Vd drain 0 1.2
Vg gate 0 0
.dc Vg 0.7 1.3 0.1
.save v(gate) @m.x1.m1[gm] @m.x1.m1[gds]
.print dc @m.x1.m1[gm] @m.x1.m1[gds]
.end
