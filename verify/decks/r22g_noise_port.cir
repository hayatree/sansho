noise with port
* Provenance: original R22g black-box regression deck. Port reference resistances, junction shot noise including the gmin branch, and port internal nodes.
Vdrive in 0 dc 0.4 ac 1 distof1 1m portnum=1 z0=50 sin(0.4 0.2 1k)
Rdrive in sense 1k
Rfeed sense out 1k
Clead sense out 10n
Rload out 0 2k
Ddet out 0 dj
Vport2 port 0 dc 0 ac 0 portnum=2 z0=50
Rport port out 100
.model dj d(is=1e-14)
.ac lin 1 1k 1k
.noise v(out) Vdrive lin 1 1k 1k 1
.end
