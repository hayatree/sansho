TXL step with mismatched terminations
* Provenance: original Sansho R18 circuit.
Vin src 0 dc 0 ac 1 pulse(0 1 1n .1n .1n 45n 100n)
Rs src near 50
Y1 near 0 far 0 wire
.model wire txl(r=16 l=250n g=.8m c=100p length=1)
Rl far 0 180
.tran .05n 36n
.save v(near) v(far) i(Vin)
.end
