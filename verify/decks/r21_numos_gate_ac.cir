Gate admittance of a biased long channel nMOS
* Provenance: original Sansho fixture, ngspice 44 manual chapter 26.
Vd d 0 0.05
Vg g 0 dc 0.9 ac 1
Mchannel d g 0 0 channel w=1 l=2u
.model channel numos
+ options mosfet defw=5u
+ x.mesh loc=0 n=1
+ x.mesh loc=0.4 n=3
+ x.mesh loc=2.4 n=13
+ x.mesh loc=2.8 n=15
+ y.mesh loc=-0.02 n=1
+ y.mesh loc=0 n=2
+ y.mesh loc=0.002 n=3
+ y.mesh loc=0.008 n=4
+ y.mesh loc=0.022 n=5
+ y.mesh loc=0.052 n=6
+ y.mesh loc=0.12 n=7
+ y.mesh loc=0.28 n=8
+ y.mesh loc=0.65 n=10
+ region num=1 mat=1 y.l=0
+ region num=2 mat=2 y.h=0
+ material num=1 silicon
+ material num=2 oxide
+ electrode num=1 ix.l=15 iy.l=2 iy.h=7
+ electrode num=2 iy.h=1
+ electrode num=3 ix.h=1 iy.l=2 iy.h=7
+ electrode num=4 iy.l=10
+ contact num=2 workf=4.5
+ doping uniform p.type conc=1e16 domains=1
+ doping uniform n.type conc=1e18 x.h=0.39 y.l=0 y.h=0.12 domains=1
+ doping uniform n.type conc=1e18 x.l=2.41 y.l=0 y.h=0.12 domains=1
+ method ac.analysis=direct
+ end
.options itl1=150 itl2=100
.ac dec 2 1k 10meg
.save i(vg) i(vd)
.end
