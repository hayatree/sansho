Level-54 common-source noise with the default NOIC
* verify: atol_v=1e-18 atol_i=1e-21
* Provenance: original R2 verification circuit.
* sansho-verify: known-difference BSIM4 4.8.2 manual Appendix A lists the NOIC default as 8.75; ngspice 44 behaves as 8.75e9
Vdd rail 0 1.8
Vin g 0 dc 0.8 ac 1
Rd rail out 2k
Mamp out g 0 0 nch w=4u l=0.5u
.model nch nmos(level=54 version=4.8 vth0=0.42 u0=0.038 toxe=3n
+ tnoimod=1 fnoimod=1 rgatemod=1 rshg=1.8 rbodymod=1)
.noise v(out) Vin dec 5 10 10meg
.end
