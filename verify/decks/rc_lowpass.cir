RC low-pass filter
* Provenance: original Sansho verification fixture.
V1 in 0 DC 1 AC 1 PULSE(0 1 0 1n 1n 5u 10u)
R1 in out 1k
C1 out 0 1n
.op
.ac dec 10 1k 10meg
.tran 10n 20u
.end
