NMOS output characteristic with body effect and series resistance
* Provenance: original Sansho verification fixture.
VDS d 0 3
VGS g 0 2
VBS b 0 -1
M1 d g 0 b nmod l=2u w=10u
.model nmod nmos vto=0.6 kp=80u gamma=0.5 phi=0.65 lambda=0.03 rd=20 rs=20
.dc VDS 0 5 0.05
.end
