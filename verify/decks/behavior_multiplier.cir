Four quadrant multiplier with differential control
* Provenance: original circuit for rs-spice release-prep verification.
.param gain=0.5
.func product(a,b) {gain*a*b}
Va a 0 DC 0 SIN(0 1 1k)
Vbias ref 0 0.2
Vb b 0 DC 0.6 SIN(0.6 0.4 2k)
Bprod out 0 V={product(v(a,ref),v(b))}
Rload out 0 1k
.dc Va -1 1 0.1
.tran 10u 2m
.end
