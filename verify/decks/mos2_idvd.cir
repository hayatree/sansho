Level 2 output characteristics at three gate biases
* Provenance: original R3 verification circuit.
Vd sweep 0 0
Vbody body 0 -0.25
Vg1 g1 0 0.9
Vs1 sweep d1 0
M1 d1 g1 0 body nch w=20u l=5u
Vg2 g2 0 1.4
Vs2 sweep d2 0
M2 d2 g2 0 body nch w=20u l=5u
Vg3 g3 0 2.0
Vs3 sweep d3 0
M3 d3 g3 0 body nch w=20u l=5u
.model nch nmos(level=2 vto=0.55 kp=80u phi=0.65 gamma=0.45 tox=30n lambda=0.018)
.save i(Vs1) i(Vs2) i(Vs3)
.dc Vd 0 2.5 0.05
.end
