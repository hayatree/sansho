Ring oscillator built from parameterized subcircuits
* Provenance: original Sansho verification fixture.
* verify: rtol_tran=3e-2
* Exercises .param, .func, nested .subckt with params:, X instances and .ic.
.param vsup=1.8 lmin=0.5u
.func wsize(k) {k*lmin*2}
.subckt inv in out vdd params: wn=1u wp=2u
MP out in vdd vdd pch l={lmin} w={wp}
MN out in 0 0 nch l={lmin} w={wn}
C1 out 0 10f
.ends
.subckt stage in out vdd params: k=1
Xi in out vdd inv wn={wsize(k)} wp={2*wsize(k)}
.ends
VDD vdd 0 {vsup}
X1 n1 n2 vdd stage k=1
X2 n2 n3 vdd stage k=1
X3 n3 n4 vdd stage k=1.5
X4 n4 n5 vdd stage
X5 n5 n1 vdd stage k=1
.ic v(n1)=0 v(n2)={vsup}
.model nch nmos vto=0.5 kp=170u gamma=0.4 phi=0.8 lambda=0.08 tox=5n cgso=0.2n cgdo=0.2n
.model pch pmos vto=-0.5 kp=60u gamma=0.4 phi=0.8 lambda=0.1 tox=5n cgso=0.2n cgdo=0.2n
.tran 10p 5n
.meas tran period TRIG v(n1) VAL=0.9 RISE=2 TARG v(n1) VAL=0.9 RISE=3
.meas tran tpd TRIG v(n1) VAL=0.9 RISE=2 TARG v(n2) VAL=0.9 FALL=2
.end
