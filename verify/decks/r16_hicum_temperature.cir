Temperature sweep of forward transport and emitter recombination
* Provenance: original Sansho R16 circuit.
Vc c 0 1
Vb b 0 .72
Q1 c b 0 0 dev
.model dev npn(level=8 tnom=25 vgb=1.16 vge=1.15 ireis=4e-15 re=2 zetare=1.2 t0=5p)
.dc temp -30 120 10
.save i(Vc) i(Vb)
.end
