Input current noise of a forward-biased diode
* verify: atol_v=1e-18 atol_i=1e-21
* Provenance: original R2 verification circuit.
Iin 0 out dc 100u ac 1
Ddet out 0 detect
.model detect d(is=1e-15 n=1 rs=2 kf=1e-15 af=1)
.noise v(out) Iin dec 6 1 1meg
.end
