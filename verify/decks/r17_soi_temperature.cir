Contact and channel currents from cold to hot
* Provenance: original Sansho R17 circuit with synthetic parameters.
Vd d 0 0.95
Vg g 0 .8
Ve e 0 0
Vb b 0 .36
M1 d g 0 e b dev l=.48u w=2.4u
.model dev nmos(level=10 version=4.4 tox=4.6n tsi=75n tbox=105n nch=1.1e17 k1=.42 vth0=.48 u0=.047 isdif=.04 isbjt=.004)
.dc temp -30 120 10
.save i(Vd) i(Vb)
.end
