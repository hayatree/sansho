Two addresses and a tristated RAM output
* Provenance: original Sansho verification circuit.
Asrc [data addr we cs] stim
Amem [data] [q] [addr] we [cs] mem
Aout [q] [out] levels
Rload0 out 0 10k
.model stim d_source(input_file="ram.dat")
.model mem d_ram(ic=0 read_delay=1n)
.model levels dac_bridge(out_low=0 out_high=1 out_undef=0.45 t_rise=0.2n t_fall=0.2n)
.tran 0.2n 26n
.save v(out)
.print tran v(out)
.end
