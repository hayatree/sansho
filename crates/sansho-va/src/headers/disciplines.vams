//! Standard analog nature and discipline declarations.
//! Provenance: original declarations based on Accellera Verilog-AMS LRM 2.4 Annex D.
`ifndef SANSHO_BUILTIN_DISCIPLINES_VAMS
`define SANSHO_BUILTIN_DISCIPLINES_VAMS
nature Voltage; access=V; units="V"; abstol=1u; idt_nature=Flux; endnature
nature Current; access=I; units="A"; abstol=1p; idt_nature=Charge; endnature
nature Charge; access=Q; units="C"; abstol=1f; ddt_nature=Current; endnature
nature Flux; access=Phi; units="Wb"; abstol=1p; ddt_nature=Voltage; endnature
nature Magneto_Motive_Force; access=MMF; units="A"; abstol=1u; endnature
nature Temperature; access=Temp; units="K"; abstol=10u; endnature
nature Power; access=Pwr; units="W"; abstol=1n; endnature
nature Position; access=Pos; units="m"; abstol=1u; ddt_nature=Velocity; endnature
nature Velocity; access=Vel; units="m/s"; abstol=1u; idt_nature=Position; ddt_nature=Acceleration; endnature
nature Acceleration; access=Acc; units="m/s^2"; abstol=1u; idt_nature=Velocity; endnature
nature Force; access=F; units="N"; abstol=1u; endnature
nature Angle; access=Theta; units="rad"; abstol=1u; ddt_nature=Angular_Velocity; endnature
nature Angular_Velocity; access=Omega; units="rad/s"; abstol=1u; idt_nature=Angle; endnature
nature Torque; access=Tau; units="N*m"; abstol=1u; endnature
discipline electrical; potential Voltage; flow Current; enddiscipline
discipline voltage; potential Voltage; enddiscipline
discipline current; flow Current; enddiscipline
discipline magnetic; potential Magneto_Motive_Force; flow Flux; enddiscipline
discipline thermal; potential Temperature; flow Power; enddiscipline
discipline kinematic; potential Position; flow Force; enddiscipline
discipline kinematic_v; potential Velocity; flow Force; enddiscipline
discipline rotational; potential Angle; flow Torque; enddiscipline
discipline rotational_omega; potential Angular_Velocity; flow Torque; enddiscipline
discipline kirchoff; potential Voltage; flow Current; enddiscipline
`endif
