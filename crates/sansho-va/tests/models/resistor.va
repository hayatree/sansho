//! Original test model. Provenance: Ohm's law and Accellera Verilog-AMS LRM 2.4.
`include "disciplines.vams"
module resistor(inout electrical p, n);
 parameter real r = 1k from (0:inf);
 analog I(p,n) <+ V(p,n)/r;
endmodule
