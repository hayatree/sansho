// Provenance: original model using sansho-devices diode/junction textbook equations;
// Accellera Verilog-AMS LRM 2.4, Nagel (1975), Antognetti & Massobrio (1993).
`include "disciplines.vams"
module vadiode(a,k);
inout a,k; electrical a,k,j;
parameter real IS=1e-14 from (0:inf), N=1 from (0:inf), RS=0 from [0:inf);
parameter real CJ0=0 from [0:inf), VJ=1 from (0:inf), M=0.5, FC=0.5 from [0:1);
parameter real TT=0 from [0:inf);
real v, vt, vc, ids, charge, arg, vfc, qfc, f2, f3;
branch (a,j) series;
analog begin
    vt=N*$vt;
    vc=vt*ln(vt/(sqrt(2)*IS));
    V(series) <+ RS*I(series);
    v=$limit(V(j,k),"pnjlim",vt,vc);
    ids=(limexp(v/vt)-1)*IS;
    charge=ids*TT;
    if (CJ0 != 0) begin
        vfc=FC*VJ;
        if (v < vfc) begin
            arg=1-v/VJ;
            if (abs(M-1) < 1e-12) charge=charge-ln(arg)*(CJ0*VJ);
            else charge=charge+(1-pow(arg,1-M))*(CJ0*VJ/(1-M));
        end else begin
            if (abs(M-1) < 1e-12) qfc=-ln(1-FC)*CJ0*VJ;
            else qfc=CJ0*VJ/(1-M)*(1-pow(1-FC,1-M));
            f2=pow(1-FC,1+M);
            f3=1-FC*(1+M);
            charge=charge+((v-vfc)*f3+(v*v-vfc*vfc)*(M/(2*VJ)))*(CJ0/f2)+qfc;
        end
    end
    I(j,k) <+ ids+v*$simparam("gmin",0)+ddt(charge);
end
endmodule
