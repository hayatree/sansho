* 1000-stage BSIM4 inverter chain
* Provenance: original circuit generated by benches/large/gen.py.
.model n1 nmos
+ level=54 version=4.8 binunit=1 paramchk=1 mobmod=0 capmod=2
+ igcmod=0 igbmod=0 geomod=0 diomod=1 rdsmod=0 rbodymod=0
+ rgatemod=0 permod=1 acnqsmod=0 trnqsmod=0 tempmod=0 tnom=27
+ toxe=2.6e-09 toxp=2.1e-09 toxm=2.6e-09 dtox=5e-10 epsrox=3.9 xj=1e-07
+ ndep=2.2e+18 ngate=1e+20 nsd=1e+20 vth0=0.36 k1=0.48 k2=0.015
+ k3=0 k3b=0 w0=2.5e-06 lpe0=6e-08 lpeb=0 dvt0=2.2
+ dvt1=0.53 dvt2=-0.032 dvt0w=0 dvt1w=5300000.0 dvt2w=-0.032 dsub=0.45
+ eta0=0.075 etab=-0.07 u0=0.032 ua=1.1e-09 ub=1.2e-18 uc=-2.5e-11
+ vsat=110000.0 a0=1.3 ags=0.22 a1=0 a2=1 b0=0
+ b1=0 keta=-0.035 rdsw=160 rdswmin=0 prwg=0.1 prwb=-0.05
+ wr=1 pclm=1.1 pdiblc1=0.32 pdiblc2=0.0055 pdiblcb=-0.02 drout=0.56
+ pvag=0.6 delta=0.012 fprout=0.2 pdits=0.1 pditsd=0.2 pditsl=1000000.0
+ nfactor=1.25 cit=0 cdsc=0.00024 cdscd=0.0001 cdscb=0 voff=-0.11
+ voffl=0 minv=0.05 lint=1.2e-08 wint=6e-09 xl=0 xw=0
+ dwg=0 dwb=0 cgso=2.1e-10 cgdo=2.1e-10 cgbo=0 cgsl=3e-11
+ cgdl=3e-11 ckappas=0.6 ckappad=0.6 cf=8e-11 clc=1e-07 cle=0.6
+ dlc=1.2e-08 dwc=6e-09 vfbcv=-1 noff=1.1 voffcv=-0.02 acde=0.6
+ moin=15 alpha0=2e-06 alpha1=0 beta0=22 agidl=2e-09 bgidl=2200000000.0
+ cgidl=0.4 egidl=0.75 jss=2e-06 jsws=2e-12 jswgs=1e-12 njs=1.02
+ xtis=3 bvs=9 xjbvs=1 cjs=0.0011 mjs=0.42 cjsws=1.1e-10
+ mjsws=0.32 cjswgs=2.2e-10 mjswgs=0.35 pbs=0.82 pbsws=0.78 pbswgs=0.85
+ kt1=-0.24 kt1l=0 kt2=-0.028 ute=-1.45 ua1=1.1e-09 ub1=-1.5e-18
+ uc1=-4e-11 at=32000.0 prt=10 tpb=0.0015 tpbsw=0.0014 tpbswg=0.0014
+ tcj=0.0008 tcjsw=0.0006 tcjswg=0.0006 rsh=6 xpart=0 ef=1
+ noia=6e+41 noib=1.5e+25 noic=880000000.0 em=41000000.0 af=1 kf=0
.model p1 pmos
+ level=54 version=4.8 binunit=1 paramchk=1 mobmod=0 capmod=2
+ igcmod=0 igbmod=0 geomod=0 diomod=1 rdsmod=0 rbodymod=0
+ rgatemod=0 permod=1 acnqsmod=0 trnqsmod=0 tempmod=0 tnom=27
+ toxe=2.6e-09 toxp=2.1e-09 toxm=2.6e-09 dtox=5e-10 epsrox=3.9 xj=1e-07
+ ndep=2.2e+18 ngate=1e+20 nsd=1e+20 vth0=-0.38 k1=0.45 k2=0.015
+ k3=0 k3b=0 w0=2.5e-06 lpe0=6e-08 lpeb=0 dvt0=2.2
+ dvt1=0.53 dvt2=-0.032 dvt0w=0 dvt1w=5300000.0 dvt2w=-0.032 dsub=0.45
+ eta0=0.06 etab=-0.07 u0=0.0095 ua=1.6e-09 ub=1e-21 uc=-4.5e-11
+ vsat=85000.0 a0=1.3 ags=0.22 a1=0 a2=1 b0=0
+ b1=0 keta=-0.035 rdsw=420 rdswmin=0 prwg=0.1 prwb=-0.05
+ wr=1 pclm=0.95 pdiblc1=0.32 pdiblc2=0.0055 pdiblcb=-0.02 drout=0.56
+ pvag=0.6 delta=0.012 fprout=0.2 pdits=0.1 pditsd=0.2 pditsl=1000000.0
+ nfactor=1.4 cit=0 cdsc=0.00024 cdscd=0.0001 cdscb=0 voff=-0.12
+ voffl=0 minv=0.05 lint=1.2e-08 wint=6e-09 xl=0 xw=0
+ dwg=0 dwb=0 cgso=2.1e-10 cgdo=2.1e-10 cgbo=0 cgsl=3e-11
+ cgdl=3e-11 ckappas=0.6 ckappad=0.6 cf=8e-11 clc=1e-07 cle=0.6
+ dlc=1.2e-08 dwc=6e-09 vfbcv=-1 noff=1.1 voffcv=-0.02 acde=0.6
+ moin=15 alpha0=1e-06 alpha1=0 beta0=24 agidl=1e-09 bgidl=2200000000.0
+ cgidl=0.4 egidl=0.75 jss=1.5e-06 jsws=2e-12 jswgs=1e-12 njs=1.02
+ xtis=3 bvs=9 xjbvs=1 cjs=0.0012 mjs=0.42 cjsws=1.1e-10
+ mjsws=0.32 cjswgs=2.2e-10 mjswgs=0.35 pbs=0.82 pbsws=0.78 pbswgs=0.85
+ kt1=-0.27 kt1l=0 kt2=-0.028 ute=-1.2 ua1=1.1e-09 ub1=-1.5e-18
+ uc1=-4e-11 at=32000.0 prt=10 tpb=0.0015 tpbsw=0.0014 tpbswg=0.0014
+ tcj=0.0008 tcjsw=0.0006 tcjswg=0.0006 rsh=6 xpart=0 ef=1
+ noia=6e+41 noib=1.5e+25 noic=880000000.0 em=41000000.0 af=1 kf=0
.subckt inv a y vdd
m0 y a vdd vdd p1 w=2u l=0.12u
m1 y a 0 0 n1 w=1u l=0.12u
cl y 0 3f
.ends
vdd vdd 0 1.8
vin n0 0 pulse(0 1.8 50p 25p 25p 300p 1n)
x0 n0 n1 vdd inv
x1 n1 n2 vdd inv
x2 n2 n3 vdd inv
x3 n3 n4 vdd inv
x4 n4 n5 vdd inv
x5 n5 n6 vdd inv
x6 n6 n7 vdd inv
x7 n7 n8 vdd inv
x8 n8 n9 vdd inv
x9 n9 n10 vdd inv
x10 n10 n11 vdd inv
x11 n11 n12 vdd inv
x12 n12 n13 vdd inv
x13 n13 n14 vdd inv
x14 n14 n15 vdd inv
x15 n15 n16 vdd inv
x16 n16 n17 vdd inv
x17 n17 n18 vdd inv
x18 n18 n19 vdd inv
x19 n19 n20 vdd inv
x20 n20 n21 vdd inv
x21 n21 n22 vdd inv
x22 n22 n23 vdd inv
x23 n23 n24 vdd inv
x24 n24 n25 vdd inv
x25 n25 n26 vdd inv
x26 n26 n27 vdd inv
x27 n27 n28 vdd inv
x28 n28 n29 vdd inv
x29 n29 n30 vdd inv
x30 n30 n31 vdd inv
x31 n31 n32 vdd inv
x32 n32 n33 vdd inv
x33 n33 n34 vdd inv
x34 n34 n35 vdd inv
x35 n35 n36 vdd inv
x36 n36 n37 vdd inv
x37 n37 n38 vdd inv
x38 n38 n39 vdd inv
x39 n39 n40 vdd inv
x40 n40 n41 vdd inv
x41 n41 n42 vdd inv
x42 n42 n43 vdd inv
x43 n43 n44 vdd inv
x44 n44 n45 vdd inv
x45 n45 n46 vdd inv
x46 n46 n47 vdd inv
x47 n47 n48 vdd inv
x48 n48 n49 vdd inv
x49 n49 n50 vdd inv
x50 n50 n51 vdd inv
x51 n51 n52 vdd inv
x52 n52 n53 vdd inv
x53 n53 n54 vdd inv
x54 n54 n55 vdd inv
x55 n55 n56 vdd inv
x56 n56 n57 vdd inv
x57 n57 n58 vdd inv
x58 n58 n59 vdd inv
x59 n59 n60 vdd inv
x60 n60 n61 vdd inv
x61 n61 n62 vdd inv
x62 n62 n63 vdd inv
x63 n63 n64 vdd inv
x64 n64 n65 vdd inv
x65 n65 n66 vdd inv
x66 n66 n67 vdd inv
x67 n67 n68 vdd inv
x68 n68 n69 vdd inv
x69 n69 n70 vdd inv
x70 n70 n71 vdd inv
x71 n71 n72 vdd inv
x72 n72 n73 vdd inv
x73 n73 n74 vdd inv
x74 n74 n75 vdd inv
x75 n75 n76 vdd inv
x76 n76 n77 vdd inv
x77 n77 n78 vdd inv
x78 n78 n79 vdd inv
x79 n79 n80 vdd inv
x80 n80 n81 vdd inv
x81 n81 n82 vdd inv
x82 n82 n83 vdd inv
x83 n83 n84 vdd inv
x84 n84 n85 vdd inv
x85 n85 n86 vdd inv
x86 n86 n87 vdd inv
x87 n87 n88 vdd inv
x88 n88 n89 vdd inv
x89 n89 n90 vdd inv
x90 n90 n91 vdd inv
x91 n91 n92 vdd inv
x92 n92 n93 vdd inv
x93 n93 n94 vdd inv
x94 n94 n95 vdd inv
x95 n95 n96 vdd inv
x96 n96 n97 vdd inv
x97 n97 n98 vdd inv
x98 n98 n99 vdd inv
x99 n99 n100 vdd inv
x100 n100 n101 vdd inv
x101 n101 n102 vdd inv
x102 n102 n103 vdd inv
x103 n103 n104 vdd inv
x104 n104 n105 vdd inv
x105 n105 n106 vdd inv
x106 n106 n107 vdd inv
x107 n107 n108 vdd inv
x108 n108 n109 vdd inv
x109 n109 n110 vdd inv
x110 n110 n111 vdd inv
x111 n111 n112 vdd inv
x112 n112 n113 vdd inv
x113 n113 n114 vdd inv
x114 n114 n115 vdd inv
x115 n115 n116 vdd inv
x116 n116 n117 vdd inv
x117 n117 n118 vdd inv
x118 n118 n119 vdd inv
x119 n119 n120 vdd inv
x120 n120 n121 vdd inv
x121 n121 n122 vdd inv
x122 n122 n123 vdd inv
x123 n123 n124 vdd inv
x124 n124 n125 vdd inv
x125 n125 n126 vdd inv
x126 n126 n127 vdd inv
x127 n127 n128 vdd inv
x128 n128 n129 vdd inv
x129 n129 n130 vdd inv
x130 n130 n131 vdd inv
x131 n131 n132 vdd inv
x132 n132 n133 vdd inv
x133 n133 n134 vdd inv
x134 n134 n135 vdd inv
x135 n135 n136 vdd inv
x136 n136 n137 vdd inv
x137 n137 n138 vdd inv
x138 n138 n139 vdd inv
x139 n139 n140 vdd inv
x140 n140 n141 vdd inv
x141 n141 n142 vdd inv
x142 n142 n143 vdd inv
x143 n143 n144 vdd inv
x144 n144 n145 vdd inv
x145 n145 n146 vdd inv
x146 n146 n147 vdd inv
x147 n147 n148 vdd inv
x148 n148 n149 vdd inv
x149 n149 n150 vdd inv
x150 n150 n151 vdd inv
x151 n151 n152 vdd inv
x152 n152 n153 vdd inv
x153 n153 n154 vdd inv
x154 n154 n155 vdd inv
x155 n155 n156 vdd inv
x156 n156 n157 vdd inv
x157 n157 n158 vdd inv
x158 n158 n159 vdd inv
x159 n159 n160 vdd inv
x160 n160 n161 vdd inv
x161 n161 n162 vdd inv
x162 n162 n163 vdd inv
x163 n163 n164 vdd inv
x164 n164 n165 vdd inv
x165 n165 n166 vdd inv
x166 n166 n167 vdd inv
x167 n167 n168 vdd inv
x168 n168 n169 vdd inv
x169 n169 n170 vdd inv
x170 n170 n171 vdd inv
x171 n171 n172 vdd inv
x172 n172 n173 vdd inv
x173 n173 n174 vdd inv
x174 n174 n175 vdd inv
x175 n175 n176 vdd inv
x176 n176 n177 vdd inv
x177 n177 n178 vdd inv
x178 n178 n179 vdd inv
x179 n179 n180 vdd inv
x180 n180 n181 vdd inv
x181 n181 n182 vdd inv
x182 n182 n183 vdd inv
x183 n183 n184 vdd inv
x184 n184 n185 vdd inv
x185 n185 n186 vdd inv
x186 n186 n187 vdd inv
x187 n187 n188 vdd inv
x188 n188 n189 vdd inv
x189 n189 n190 vdd inv
x190 n190 n191 vdd inv
x191 n191 n192 vdd inv
x192 n192 n193 vdd inv
x193 n193 n194 vdd inv
x194 n194 n195 vdd inv
x195 n195 n196 vdd inv
x196 n196 n197 vdd inv
x197 n197 n198 vdd inv
x198 n198 n199 vdd inv
x199 n199 n200 vdd inv
x200 n200 n201 vdd inv
x201 n201 n202 vdd inv
x202 n202 n203 vdd inv
x203 n203 n204 vdd inv
x204 n204 n205 vdd inv
x205 n205 n206 vdd inv
x206 n206 n207 vdd inv
x207 n207 n208 vdd inv
x208 n208 n209 vdd inv
x209 n209 n210 vdd inv
x210 n210 n211 vdd inv
x211 n211 n212 vdd inv
x212 n212 n213 vdd inv
x213 n213 n214 vdd inv
x214 n214 n215 vdd inv
x215 n215 n216 vdd inv
x216 n216 n217 vdd inv
x217 n217 n218 vdd inv
x218 n218 n219 vdd inv
x219 n219 n220 vdd inv
x220 n220 n221 vdd inv
x221 n221 n222 vdd inv
x222 n222 n223 vdd inv
x223 n223 n224 vdd inv
x224 n224 n225 vdd inv
x225 n225 n226 vdd inv
x226 n226 n227 vdd inv
x227 n227 n228 vdd inv
x228 n228 n229 vdd inv
x229 n229 n230 vdd inv
x230 n230 n231 vdd inv
x231 n231 n232 vdd inv
x232 n232 n233 vdd inv
x233 n233 n234 vdd inv
x234 n234 n235 vdd inv
x235 n235 n236 vdd inv
x236 n236 n237 vdd inv
x237 n237 n238 vdd inv
x238 n238 n239 vdd inv
x239 n239 n240 vdd inv
x240 n240 n241 vdd inv
x241 n241 n242 vdd inv
x242 n242 n243 vdd inv
x243 n243 n244 vdd inv
x244 n244 n245 vdd inv
x245 n245 n246 vdd inv
x246 n246 n247 vdd inv
x247 n247 n248 vdd inv
x248 n248 n249 vdd inv
x249 n249 n250 vdd inv
x250 n250 n251 vdd inv
x251 n251 n252 vdd inv
x252 n252 n253 vdd inv
x253 n253 n254 vdd inv
x254 n254 n255 vdd inv
x255 n255 n256 vdd inv
x256 n256 n257 vdd inv
x257 n257 n258 vdd inv
x258 n258 n259 vdd inv
x259 n259 n260 vdd inv
x260 n260 n261 vdd inv
x261 n261 n262 vdd inv
x262 n262 n263 vdd inv
x263 n263 n264 vdd inv
x264 n264 n265 vdd inv
x265 n265 n266 vdd inv
x266 n266 n267 vdd inv
x267 n267 n268 vdd inv
x268 n268 n269 vdd inv
x269 n269 n270 vdd inv
x270 n270 n271 vdd inv
x271 n271 n272 vdd inv
x272 n272 n273 vdd inv
x273 n273 n274 vdd inv
x274 n274 n275 vdd inv
x275 n275 n276 vdd inv
x276 n276 n277 vdd inv
x277 n277 n278 vdd inv
x278 n278 n279 vdd inv
x279 n279 n280 vdd inv
x280 n280 n281 vdd inv
x281 n281 n282 vdd inv
x282 n282 n283 vdd inv
x283 n283 n284 vdd inv
x284 n284 n285 vdd inv
x285 n285 n286 vdd inv
x286 n286 n287 vdd inv
x287 n287 n288 vdd inv
x288 n288 n289 vdd inv
x289 n289 n290 vdd inv
x290 n290 n291 vdd inv
x291 n291 n292 vdd inv
x292 n292 n293 vdd inv
x293 n293 n294 vdd inv
x294 n294 n295 vdd inv
x295 n295 n296 vdd inv
x296 n296 n297 vdd inv
x297 n297 n298 vdd inv
x298 n298 n299 vdd inv
x299 n299 n300 vdd inv
x300 n300 n301 vdd inv
x301 n301 n302 vdd inv
x302 n302 n303 vdd inv
x303 n303 n304 vdd inv
x304 n304 n305 vdd inv
x305 n305 n306 vdd inv
x306 n306 n307 vdd inv
x307 n307 n308 vdd inv
x308 n308 n309 vdd inv
x309 n309 n310 vdd inv
x310 n310 n311 vdd inv
x311 n311 n312 vdd inv
x312 n312 n313 vdd inv
x313 n313 n314 vdd inv
x314 n314 n315 vdd inv
x315 n315 n316 vdd inv
x316 n316 n317 vdd inv
x317 n317 n318 vdd inv
x318 n318 n319 vdd inv
x319 n319 n320 vdd inv
x320 n320 n321 vdd inv
x321 n321 n322 vdd inv
x322 n322 n323 vdd inv
x323 n323 n324 vdd inv
x324 n324 n325 vdd inv
x325 n325 n326 vdd inv
x326 n326 n327 vdd inv
x327 n327 n328 vdd inv
x328 n328 n329 vdd inv
x329 n329 n330 vdd inv
x330 n330 n331 vdd inv
x331 n331 n332 vdd inv
x332 n332 n333 vdd inv
x333 n333 n334 vdd inv
x334 n334 n335 vdd inv
x335 n335 n336 vdd inv
x336 n336 n337 vdd inv
x337 n337 n338 vdd inv
x338 n338 n339 vdd inv
x339 n339 n340 vdd inv
x340 n340 n341 vdd inv
x341 n341 n342 vdd inv
x342 n342 n343 vdd inv
x343 n343 n344 vdd inv
x344 n344 n345 vdd inv
x345 n345 n346 vdd inv
x346 n346 n347 vdd inv
x347 n347 n348 vdd inv
x348 n348 n349 vdd inv
x349 n349 n350 vdd inv
x350 n350 n351 vdd inv
x351 n351 n352 vdd inv
x352 n352 n353 vdd inv
x353 n353 n354 vdd inv
x354 n354 n355 vdd inv
x355 n355 n356 vdd inv
x356 n356 n357 vdd inv
x357 n357 n358 vdd inv
x358 n358 n359 vdd inv
x359 n359 n360 vdd inv
x360 n360 n361 vdd inv
x361 n361 n362 vdd inv
x362 n362 n363 vdd inv
x363 n363 n364 vdd inv
x364 n364 n365 vdd inv
x365 n365 n366 vdd inv
x366 n366 n367 vdd inv
x367 n367 n368 vdd inv
x368 n368 n369 vdd inv
x369 n369 n370 vdd inv
x370 n370 n371 vdd inv
x371 n371 n372 vdd inv
x372 n372 n373 vdd inv
x373 n373 n374 vdd inv
x374 n374 n375 vdd inv
x375 n375 n376 vdd inv
x376 n376 n377 vdd inv
x377 n377 n378 vdd inv
x378 n378 n379 vdd inv
x379 n379 n380 vdd inv
x380 n380 n381 vdd inv
x381 n381 n382 vdd inv
x382 n382 n383 vdd inv
x383 n383 n384 vdd inv
x384 n384 n385 vdd inv
x385 n385 n386 vdd inv
x386 n386 n387 vdd inv
x387 n387 n388 vdd inv
x388 n388 n389 vdd inv
x389 n389 n390 vdd inv
x390 n390 n391 vdd inv
x391 n391 n392 vdd inv
x392 n392 n393 vdd inv
x393 n393 n394 vdd inv
x394 n394 n395 vdd inv
x395 n395 n396 vdd inv
x396 n396 n397 vdd inv
x397 n397 n398 vdd inv
x398 n398 n399 vdd inv
x399 n399 n400 vdd inv
x400 n400 n401 vdd inv
x401 n401 n402 vdd inv
x402 n402 n403 vdd inv
x403 n403 n404 vdd inv
x404 n404 n405 vdd inv
x405 n405 n406 vdd inv
x406 n406 n407 vdd inv
x407 n407 n408 vdd inv
x408 n408 n409 vdd inv
x409 n409 n410 vdd inv
x410 n410 n411 vdd inv
x411 n411 n412 vdd inv
x412 n412 n413 vdd inv
x413 n413 n414 vdd inv
x414 n414 n415 vdd inv
x415 n415 n416 vdd inv
x416 n416 n417 vdd inv
x417 n417 n418 vdd inv
x418 n418 n419 vdd inv
x419 n419 n420 vdd inv
x420 n420 n421 vdd inv
x421 n421 n422 vdd inv
x422 n422 n423 vdd inv
x423 n423 n424 vdd inv
x424 n424 n425 vdd inv
x425 n425 n426 vdd inv
x426 n426 n427 vdd inv
x427 n427 n428 vdd inv
x428 n428 n429 vdd inv
x429 n429 n430 vdd inv
x430 n430 n431 vdd inv
x431 n431 n432 vdd inv
x432 n432 n433 vdd inv
x433 n433 n434 vdd inv
x434 n434 n435 vdd inv
x435 n435 n436 vdd inv
x436 n436 n437 vdd inv
x437 n437 n438 vdd inv
x438 n438 n439 vdd inv
x439 n439 n440 vdd inv
x440 n440 n441 vdd inv
x441 n441 n442 vdd inv
x442 n442 n443 vdd inv
x443 n443 n444 vdd inv
x444 n444 n445 vdd inv
x445 n445 n446 vdd inv
x446 n446 n447 vdd inv
x447 n447 n448 vdd inv
x448 n448 n449 vdd inv
x449 n449 n450 vdd inv
x450 n450 n451 vdd inv
x451 n451 n452 vdd inv
x452 n452 n453 vdd inv
x453 n453 n454 vdd inv
x454 n454 n455 vdd inv
x455 n455 n456 vdd inv
x456 n456 n457 vdd inv
x457 n457 n458 vdd inv
x458 n458 n459 vdd inv
x459 n459 n460 vdd inv
x460 n460 n461 vdd inv
x461 n461 n462 vdd inv
x462 n462 n463 vdd inv
x463 n463 n464 vdd inv
x464 n464 n465 vdd inv
x465 n465 n466 vdd inv
x466 n466 n467 vdd inv
x467 n467 n468 vdd inv
x468 n468 n469 vdd inv
x469 n469 n470 vdd inv
x470 n470 n471 vdd inv
x471 n471 n472 vdd inv
x472 n472 n473 vdd inv
x473 n473 n474 vdd inv
x474 n474 n475 vdd inv
x475 n475 n476 vdd inv
x476 n476 n477 vdd inv
x477 n477 n478 vdd inv
x478 n478 n479 vdd inv
x479 n479 n480 vdd inv
x480 n480 n481 vdd inv
x481 n481 n482 vdd inv
x482 n482 n483 vdd inv
x483 n483 n484 vdd inv
x484 n484 n485 vdd inv
x485 n485 n486 vdd inv
x486 n486 n487 vdd inv
x487 n487 n488 vdd inv
x488 n488 n489 vdd inv
x489 n489 n490 vdd inv
x490 n490 n491 vdd inv
x491 n491 n492 vdd inv
x492 n492 n493 vdd inv
x493 n493 n494 vdd inv
x494 n494 n495 vdd inv
x495 n495 n496 vdd inv
x496 n496 n497 vdd inv
x497 n497 n498 vdd inv
x498 n498 n499 vdd inv
x499 n499 n500 vdd inv
x500 n500 n501 vdd inv
x501 n501 n502 vdd inv
x502 n502 n503 vdd inv
x503 n503 n504 vdd inv
x504 n504 n505 vdd inv
x505 n505 n506 vdd inv
x506 n506 n507 vdd inv
x507 n507 n508 vdd inv
x508 n508 n509 vdd inv
x509 n509 n510 vdd inv
x510 n510 n511 vdd inv
x511 n511 n512 vdd inv
x512 n512 n513 vdd inv
x513 n513 n514 vdd inv
x514 n514 n515 vdd inv
x515 n515 n516 vdd inv
x516 n516 n517 vdd inv
x517 n517 n518 vdd inv
x518 n518 n519 vdd inv
x519 n519 n520 vdd inv
x520 n520 n521 vdd inv
x521 n521 n522 vdd inv
x522 n522 n523 vdd inv
x523 n523 n524 vdd inv
x524 n524 n525 vdd inv
x525 n525 n526 vdd inv
x526 n526 n527 vdd inv
x527 n527 n528 vdd inv
x528 n528 n529 vdd inv
x529 n529 n530 vdd inv
x530 n530 n531 vdd inv
x531 n531 n532 vdd inv
x532 n532 n533 vdd inv
x533 n533 n534 vdd inv
x534 n534 n535 vdd inv
x535 n535 n536 vdd inv
x536 n536 n537 vdd inv
x537 n537 n538 vdd inv
x538 n538 n539 vdd inv
x539 n539 n540 vdd inv
x540 n540 n541 vdd inv
x541 n541 n542 vdd inv
x542 n542 n543 vdd inv
x543 n543 n544 vdd inv
x544 n544 n545 vdd inv
x545 n545 n546 vdd inv
x546 n546 n547 vdd inv
x547 n547 n548 vdd inv
x548 n548 n549 vdd inv
x549 n549 n550 vdd inv
x550 n550 n551 vdd inv
x551 n551 n552 vdd inv
x552 n552 n553 vdd inv
x553 n553 n554 vdd inv
x554 n554 n555 vdd inv
x555 n555 n556 vdd inv
x556 n556 n557 vdd inv
x557 n557 n558 vdd inv
x558 n558 n559 vdd inv
x559 n559 n560 vdd inv
x560 n560 n561 vdd inv
x561 n561 n562 vdd inv
x562 n562 n563 vdd inv
x563 n563 n564 vdd inv
x564 n564 n565 vdd inv
x565 n565 n566 vdd inv
x566 n566 n567 vdd inv
x567 n567 n568 vdd inv
x568 n568 n569 vdd inv
x569 n569 n570 vdd inv
x570 n570 n571 vdd inv
x571 n571 n572 vdd inv
x572 n572 n573 vdd inv
x573 n573 n574 vdd inv
x574 n574 n575 vdd inv
x575 n575 n576 vdd inv
x576 n576 n577 vdd inv
x577 n577 n578 vdd inv
x578 n578 n579 vdd inv
x579 n579 n580 vdd inv
x580 n580 n581 vdd inv
x581 n581 n582 vdd inv
x582 n582 n583 vdd inv
x583 n583 n584 vdd inv
x584 n584 n585 vdd inv
x585 n585 n586 vdd inv
x586 n586 n587 vdd inv
x587 n587 n588 vdd inv
x588 n588 n589 vdd inv
x589 n589 n590 vdd inv
x590 n590 n591 vdd inv
x591 n591 n592 vdd inv
x592 n592 n593 vdd inv
x593 n593 n594 vdd inv
x594 n594 n595 vdd inv
x595 n595 n596 vdd inv
x596 n596 n597 vdd inv
x597 n597 n598 vdd inv
x598 n598 n599 vdd inv
x599 n599 n600 vdd inv
x600 n600 n601 vdd inv
x601 n601 n602 vdd inv
x602 n602 n603 vdd inv
x603 n603 n604 vdd inv
x604 n604 n605 vdd inv
x605 n605 n606 vdd inv
x606 n606 n607 vdd inv
x607 n607 n608 vdd inv
x608 n608 n609 vdd inv
x609 n609 n610 vdd inv
x610 n610 n611 vdd inv
x611 n611 n612 vdd inv
x612 n612 n613 vdd inv
x613 n613 n614 vdd inv
x614 n614 n615 vdd inv
x615 n615 n616 vdd inv
x616 n616 n617 vdd inv
x617 n617 n618 vdd inv
x618 n618 n619 vdd inv
x619 n619 n620 vdd inv
x620 n620 n621 vdd inv
x621 n621 n622 vdd inv
x622 n622 n623 vdd inv
x623 n623 n624 vdd inv
x624 n624 n625 vdd inv
x625 n625 n626 vdd inv
x626 n626 n627 vdd inv
x627 n627 n628 vdd inv
x628 n628 n629 vdd inv
x629 n629 n630 vdd inv
x630 n630 n631 vdd inv
x631 n631 n632 vdd inv
x632 n632 n633 vdd inv
x633 n633 n634 vdd inv
x634 n634 n635 vdd inv
x635 n635 n636 vdd inv
x636 n636 n637 vdd inv
x637 n637 n638 vdd inv
x638 n638 n639 vdd inv
x639 n639 n640 vdd inv
x640 n640 n641 vdd inv
x641 n641 n642 vdd inv
x642 n642 n643 vdd inv
x643 n643 n644 vdd inv
x644 n644 n645 vdd inv
x645 n645 n646 vdd inv
x646 n646 n647 vdd inv
x647 n647 n648 vdd inv
x648 n648 n649 vdd inv
x649 n649 n650 vdd inv
x650 n650 n651 vdd inv
x651 n651 n652 vdd inv
x652 n652 n653 vdd inv
x653 n653 n654 vdd inv
x654 n654 n655 vdd inv
x655 n655 n656 vdd inv
x656 n656 n657 vdd inv
x657 n657 n658 vdd inv
x658 n658 n659 vdd inv
x659 n659 n660 vdd inv
x660 n660 n661 vdd inv
x661 n661 n662 vdd inv
x662 n662 n663 vdd inv
x663 n663 n664 vdd inv
x664 n664 n665 vdd inv
x665 n665 n666 vdd inv
x666 n666 n667 vdd inv
x667 n667 n668 vdd inv
x668 n668 n669 vdd inv
x669 n669 n670 vdd inv
x670 n670 n671 vdd inv
x671 n671 n672 vdd inv
x672 n672 n673 vdd inv
x673 n673 n674 vdd inv
x674 n674 n675 vdd inv
x675 n675 n676 vdd inv
x676 n676 n677 vdd inv
x677 n677 n678 vdd inv
x678 n678 n679 vdd inv
x679 n679 n680 vdd inv
x680 n680 n681 vdd inv
x681 n681 n682 vdd inv
x682 n682 n683 vdd inv
x683 n683 n684 vdd inv
x684 n684 n685 vdd inv
x685 n685 n686 vdd inv
x686 n686 n687 vdd inv
x687 n687 n688 vdd inv
x688 n688 n689 vdd inv
x689 n689 n690 vdd inv
x690 n690 n691 vdd inv
x691 n691 n692 vdd inv
x692 n692 n693 vdd inv
x693 n693 n694 vdd inv
x694 n694 n695 vdd inv
x695 n695 n696 vdd inv
x696 n696 n697 vdd inv
x697 n697 n698 vdd inv
x698 n698 n699 vdd inv
x699 n699 n700 vdd inv
x700 n700 n701 vdd inv
x701 n701 n702 vdd inv
x702 n702 n703 vdd inv
x703 n703 n704 vdd inv
x704 n704 n705 vdd inv
x705 n705 n706 vdd inv
x706 n706 n707 vdd inv
x707 n707 n708 vdd inv
x708 n708 n709 vdd inv
x709 n709 n710 vdd inv
x710 n710 n711 vdd inv
x711 n711 n712 vdd inv
x712 n712 n713 vdd inv
x713 n713 n714 vdd inv
x714 n714 n715 vdd inv
x715 n715 n716 vdd inv
x716 n716 n717 vdd inv
x717 n717 n718 vdd inv
x718 n718 n719 vdd inv
x719 n719 n720 vdd inv
x720 n720 n721 vdd inv
x721 n721 n722 vdd inv
x722 n722 n723 vdd inv
x723 n723 n724 vdd inv
x724 n724 n725 vdd inv
x725 n725 n726 vdd inv
x726 n726 n727 vdd inv
x727 n727 n728 vdd inv
x728 n728 n729 vdd inv
x729 n729 n730 vdd inv
x730 n730 n731 vdd inv
x731 n731 n732 vdd inv
x732 n732 n733 vdd inv
x733 n733 n734 vdd inv
x734 n734 n735 vdd inv
x735 n735 n736 vdd inv
x736 n736 n737 vdd inv
x737 n737 n738 vdd inv
x738 n738 n739 vdd inv
x739 n739 n740 vdd inv
x740 n740 n741 vdd inv
x741 n741 n742 vdd inv
x742 n742 n743 vdd inv
x743 n743 n744 vdd inv
x744 n744 n745 vdd inv
x745 n745 n746 vdd inv
x746 n746 n747 vdd inv
x747 n747 n748 vdd inv
x748 n748 n749 vdd inv
x749 n749 n750 vdd inv
x750 n750 n751 vdd inv
x751 n751 n752 vdd inv
x752 n752 n753 vdd inv
x753 n753 n754 vdd inv
x754 n754 n755 vdd inv
x755 n755 n756 vdd inv
x756 n756 n757 vdd inv
x757 n757 n758 vdd inv
x758 n758 n759 vdd inv
x759 n759 n760 vdd inv
x760 n760 n761 vdd inv
x761 n761 n762 vdd inv
x762 n762 n763 vdd inv
x763 n763 n764 vdd inv
x764 n764 n765 vdd inv
x765 n765 n766 vdd inv
x766 n766 n767 vdd inv
x767 n767 n768 vdd inv
x768 n768 n769 vdd inv
x769 n769 n770 vdd inv
x770 n770 n771 vdd inv
x771 n771 n772 vdd inv
x772 n772 n773 vdd inv
x773 n773 n774 vdd inv
x774 n774 n775 vdd inv
x775 n775 n776 vdd inv
x776 n776 n777 vdd inv
x777 n777 n778 vdd inv
x778 n778 n779 vdd inv
x779 n779 n780 vdd inv
x780 n780 n781 vdd inv
x781 n781 n782 vdd inv
x782 n782 n783 vdd inv
x783 n783 n784 vdd inv
x784 n784 n785 vdd inv
x785 n785 n786 vdd inv
x786 n786 n787 vdd inv
x787 n787 n788 vdd inv
x788 n788 n789 vdd inv
x789 n789 n790 vdd inv
x790 n790 n791 vdd inv
x791 n791 n792 vdd inv
x792 n792 n793 vdd inv
x793 n793 n794 vdd inv
x794 n794 n795 vdd inv
x795 n795 n796 vdd inv
x796 n796 n797 vdd inv
x797 n797 n798 vdd inv
x798 n798 n799 vdd inv
x799 n799 n800 vdd inv
x800 n800 n801 vdd inv
x801 n801 n802 vdd inv
x802 n802 n803 vdd inv
x803 n803 n804 vdd inv
x804 n804 n805 vdd inv
x805 n805 n806 vdd inv
x806 n806 n807 vdd inv
x807 n807 n808 vdd inv
x808 n808 n809 vdd inv
x809 n809 n810 vdd inv
x810 n810 n811 vdd inv
x811 n811 n812 vdd inv
x812 n812 n813 vdd inv
x813 n813 n814 vdd inv
x814 n814 n815 vdd inv
x815 n815 n816 vdd inv
x816 n816 n817 vdd inv
x817 n817 n818 vdd inv
x818 n818 n819 vdd inv
x819 n819 n820 vdd inv
x820 n820 n821 vdd inv
x821 n821 n822 vdd inv
x822 n822 n823 vdd inv
x823 n823 n824 vdd inv
x824 n824 n825 vdd inv
x825 n825 n826 vdd inv
x826 n826 n827 vdd inv
x827 n827 n828 vdd inv
x828 n828 n829 vdd inv
x829 n829 n830 vdd inv
x830 n830 n831 vdd inv
x831 n831 n832 vdd inv
x832 n832 n833 vdd inv
x833 n833 n834 vdd inv
x834 n834 n835 vdd inv
x835 n835 n836 vdd inv
x836 n836 n837 vdd inv
x837 n837 n838 vdd inv
x838 n838 n839 vdd inv
x839 n839 n840 vdd inv
x840 n840 n841 vdd inv
x841 n841 n842 vdd inv
x842 n842 n843 vdd inv
x843 n843 n844 vdd inv
x844 n844 n845 vdd inv
x845 n845 n846 vdd inv
x846 n846 n847 vdd inv
x847 n847 n848 vdd inv
x848 n848 n849 vdd inv
x849 n849 n850 vdd inv
x850 n850 n851 vdd inv
x851 n851 n852 vdd inv
x852 n852 n853 vdd inv
x853 n853 n854 vdd inv
x854 n854 n855 vdd inv
x855 n855 n856 vdd inv
x856 n856 n857 vdd inv
x857 n857 n858 vdd inv
x858 n858 n859 vdd inv
x859 n859 n860 vdd inv
x860 n860 n861 vdd inv
x861 n861 n862 vdd inv
x862 n862 n863 vdd inv
x863 n863 n864 vdd inv
x864 n864 n865 vdd inv
x865 n865 n866 vdd inv
x866 n866 n867 vdd inv
x867 n867 n868 vdd inv
x868 n868 n869 vdd inv
x869 n869 n870 vdd inv
x870 n870 n871 vdd inv
x871 n871 n872 vdd inv
x872 n872 n873 vdd inv
x873 n873 n874 vdd inv
x874 n874 n875 vdd inv
x875 n875 n876 vdd inv
x876 n876 n877 vdd inv
x877 n877 n878 vdd inv
x878 n878 n879 vdd inv
x879 n879 n880 vdd inv
x880 n880 n881 vdd inv
x881 n881 n882 vdd inv
x882 n882 n883 vdd inv
x883 n883 n884 vdd inv
x884 n884 n885 vdd inv
x885 n885 n886 vdd inv
x886 n886 n887 vdd inv
x887 n887 n888 vdd inv
x888 n888 n889 vdd inv
x889 n889 n890 vdd inv
x890 n890 n891 vdd inv
x891 n891 n892 vdd inv
x892 n892 n893 vdd inv
x893 n893 n894 vdd inv
x894 n894 n895 vdd inv
x895 n895 n896 vdd inv
x896 n896 n897 vdd inv
x897 n897 n898 vdd inv
x898 n898 n899 vdd inv
x899 n899 n900 vdd inv
x900 n900 n901 vdd inv
x901 n901 n902 vdd inv
x902 n902 n903 vdd inv
x903 n903 n904 vdd inv
x904 n904 n905 vdd inv
x905 n905 n906 vdd inv
x906 n906 n907 vdd inv
x907 n907 n908 vdd inv
x908 n908 n909 vdd inv
x909 n909 n910 vdd inv
x910 n910 n911 vdd inv
x911 n911 n912 vdd inv
x912 n912 n913 vdd inv
x913 n913 n914 vdd inv
x914 n914 n915 vdd inv
x915 n915 n916 vdd inv
x916 n916 n917 vdd inv
x917 n917 n918 vdd inv
x918 n918 n919 vdd inv
x919 n919 n920 vdd inv
x920 n920 n921 vdd inv
x921 n921 n922 vdd inv
x922 n922 n923 vdd inv
x923 n923 n924 vdd inv
x924 n924 n925 vdd inv
x925 n925 n926 vdd inv
x926 n926 n927 vdd inv
x927 n927 n928 vdd inv
x928 n928 n929 vdd inv
x929 n929 n930 vdd inv
x930 n930 n931 vdd inv
x931 n931 n932 vdd inv
x932 n932 n933 vdd inv
x933 n933 n934 vdd inv
x934 n934 n935 vdd inv
x935 n935 n936 vdd inv
x936 n936 n937 vdd inv
x937 n937 n938 vdd inv
x938 n938 n939 vdd inv
x939 n939 n940 vdd inv
x940 n940 n941 vdd inv
x941 n941 n942 vdd inv
x942 n942 n943 vdd inv
x943 n943 n944 vdd inv
x944 n944 n945 vdd inv
x945 n945 n946 vdd inv
x946 n946 n947 vdd inv
x947 n947 n948 vdd inv
x948 n948 n949 vdd inv
x949 n949 n950 vdd inv
x950 n950 n951 vdd inv
x951 n951 n952 vdd inv
x952 n952 n953 vdd inv
x953 n953 n954 vdd inv
x954 n954 n955 vdd inv
x955 n955 n956 vdd inv
x956 n956 n957 vdd inv
x957 n957 n958 vdd inv
x958 n958 n959 vdd inv
x959 n959 n960 vdd inv
x960 n960 n961 vdd inv
x961 n961 n962 vdd inv
x962 n962 n963 vdd inv
x963 n963 n964 vdd inv
x964 n964 n965 vdd inv
x965 n965 n966 vdd inv
x966 n966 n967 vdd inv
x967 n967 n968 vdd inv
x968 n968 n969 vdd inv
x969 n969 n970 vdd inv
x970 n970 n971 vdd inv
x971 n971 n972 vdd inv
x972 n972 n973 vdd inv
x973 n973 n974 vdd inv
x974 n974 n975 vdd inv
x975 n975 n976 vdd inv
x976 n976 n977 vdd inv
x977 n977 n978 vdd inv
x978 n978 n979 vdd inv
x979 n979 n980 vdd inv
x980 n980 n981 vdd inv
x981 n981 n982 vdd inv
x982 n982 n983 vdd inv
x983 n983 n984 vdd inv
x984 n984 n985 vdd inv
x985 n985 n986 vdd inv
x986 n986 n987 vdd inv
x987 n987 n988 vdd inv
x988 n988 n989 vdd inv
x989 n989 n990 vdd inv
x990 n990 n991 vdd inv
x991 n991 n992 vdd inv
x992 n992 n993 vdd inv
x993 n993 n994 vdd inv
x994 n994 n995 vdd inv
x995 n995 n996 vdd inv
x996 n996 n997 vdd inv
x997 n997 n998 vdd inv
x998 n998 n999 vdd inv
x999 n999 n1000 vdd inv
.ic v(vdd)=1.8
.ic v(n1)=1.8
.ic v(n3)=1.8
.ic v(n5)=1.8
.ic v(n7)=1.8
.ic v(n9)=1.8
.ic v(n11)=1.8
.ic v(n13)=1.8
.ic v(n15)=1.8
.ic v(n17)=1.8
.ic v(n19)=1.8
.ic v(n21)=1.8
.ic v(n23)=1.8
.ic v(n25)=1.8
.ic v(n27)=1.8
.ic v(n29)=1.8
.ic v(n31)=1.8
.ic v(n33)=1.8
.ic v(n35)=1.8
.ic v(n37)=1.8
.ic v(n39)=1.8
.ic v(n41)=1.8
.ic v(n43)=1.8
.ic v(n45)=1.8
.ic v(n47)=1.8
.ic v(n49)=1.8
.ic v(n51)=1.8
.ic v(n53)=1.8
.ic v(n55)=1.8
.ic v(n57)=1.8
.ic v(n59)=1.8
.ic v(n61)=1.8
.ic v(n63)=1.8
.ic v(n65)=1.8
.ic v(n67)=1.8
.ic v(n69)=1.8
.ic v(n71)=1.8
.ic v(n73)=1.8
.ic v(n75)=1.8
.ic v(n77)=1.8
.ic v(n79)=1.8
.ic v(n81)=1.8
.ic v(n83)=1.8
.ic v(n85)=1.8
.ic v(n87)=1.8
.ic v(n89)=1.8
.ic v(n91)=1.8
.ic v(n93)=1.8
.ic v(n95)=1.8
.ic v(n97)=1.8
.ic v(n99)=1.8
.ic v(n101)=1.8
.ic v(n103)=1.8
.ic v(n105)=1.8
.ic v(n107)=1.8
.ic v(n109)=1.8
.ic v(n111)=1.8
.ic v(n113)=1.8
.ic v(n115)=1.8
.ic v(n117)=1.8
.ic v(n119)=1.8
.ic v(n121)=1.8
.ic v(n123)=1.8
.ic v(n125)=1.8
.ic v(n127)=1.8
.ic v(n129)=1.8
.ic v(n131)=1.8
.ic v(n133)=1.8
.ic v(n135)=1.8
.ic v(n137)=1.8
.ic v(n139)=1.8
.ic v(n141)=1.8
.ic v(n143)=1.8
.ic v(n145)=1.8
.ic v(n147)=1.8
.ic v(n149)=1.8
.ic v(n151)=1.8
.ic v(n153)=1.8
.ic v(n155)=1.8
.ic v(n157)=1.8
.ic v(n159)=1.8
.ic v(n161)=1.8
.ic v(n163)=1.8
.ic v(n165)=1.8
.ic v(n167)=1.8
.ic v(n169)=1.8
.ic v(n171)=1.8
.ic v(n173)=1.8
.ic v(n175)=1.8
.ic v(n177)=1.8
.ic v(n179)=1.8
.ic v(n181)=1.8
.ic v(n183)=1.8
.ic v(n185)=1.8
.ic v(n187)=1.8
.ic v(n189)=1.8
.ic v(n191)=1.8
.ic v(n193)=1.8
.ic v(n195)=1.8
.ic v(n197)=1.8
.ic v(n199)=1.8
.ic v(n201)=1.8
.ic v(n203)=1.8
.ic v(n205)=1.8
.ic v(n207)=1.8
.ic v(n209)=1.8
.ic v(n211)=1.8
.ic v(n213)=1.8
.ic v(n215)=1.8
.ic v(n217)=1.8
.ic v(n219)=1.8
.ic v(n221)=1.8
.ic v(n223)=1.8
.ic v(n225)=1.8
.ic v(n227)=1.8
.ic v(n229)=1.8
.ic v(n231)=1.8
.ic v(n233)=1.8
.ic v(n235)=1.8
.ic v(n237)=1.8
.ic v(n239)=1.8
.ic v(n241)=1.8
.ic v(n243)=1.8
.ic v(n245)=1.8
.ic v(n247)=1.8
.ic v(n249)=1.8
.ic v(n251)=1.8
.ic v(n253)=1.8
.ic v(n255)=1.8
.ic v(n257)=1.8
.ic v(n259)=1.8
.ic v(n261)=1.8
.ic v(n263)=1.8
.ic v(n265)=1.8
.ic v(n267)=1.8
.ic v(n269)=1.8
.ic v(n271)=1.8
.ic v(n273)=1.8
.ic v(n275)=1.8
.ic v(n277)=1.8
.ic v(n279)=1.8
.ic v(n281)=1.8
.ic v(n283)=1.8
.ic v(n285)=1.8
.ic v(n287)=1.8
.ic v(n289)=1.8
.ic v(n291)=1.8
.ic v(n293)=1.8
.ic v(n295)=1.8
.ic v(n297)=1.8
.ic v(n299)=1.8
.ic v(n301)=1.8
.ic v(n303)=1.8
.ic v(n305)=1.8
.ic v(n307)=1.8
.ic v(n309)=1.8
.ic v(n311)=1.8
.ic v(n313)=1.8
.ic v(n315)=1.8
.ic v(n317)=1.8
.ic v(n319)=1.8
.ic v(n321)=1.8
.ic v(n323)=1.8
.ic v(n325)=1.8
.ic v(n327)=1.8
.ic v(n329)=1.8
.ic v(n331)=1.8
.ic v(n333)=1.8
.ic v(n335)=1.8
.ic v(n337)=1.8
.ic v(n339)=1.8
.ic v(n341)=1.8
.ic v(n343)=1.8
.ic v(n345)=1.8
.ic v(n347)=1.8
.ic v(n349)=1.8
.ic v(n351)=1.8
.ic v(n353)=1.8
.ic v(n355)=1.8
.ic v(n357)=1.8
.ic v(n359)=1.8
.ic v(n361)=1.8
.ic v(n363)=1.8
.ic v(n365)=1.8
.ic v(n367)=1.8
.ic v(n369)=1.8
.ic v(n371)=1.8
.ic v(n373)=1.8
.ic v(n375)=1.8
.ic v(n377)=1.8
.ic v(n379)=1.8
.ic v(n381)=1.8
.ic v(n383)=1.8
.ic v(n385)=1.8
.ic v(n387)=1.8
.ic v(n389)=1.8
.ic v(n391)=1.8
.ic v(n393)=1.8
.ic v(n395)=1.8
.ic v(n397)=1.8
.ic v(n399)=1.8
.ic v(n401)=1.8
.ic v(n403)=1.8
.ic v(n405)=1.8
.ic v(n407)=1.8
.ic v(n409)=1.8
.ic v(n411)=1.8
.ic v(n413)=1.8
.ic v(n415)=1.8
.ic v(n417)=1.8
.ic v(n419)=1.8
.ic v(n421)=1.8
.ic v(n423)=1.8
.ic v(n425)=1.8
.ic v(n427)=1.8
.ic v(n429)=1.8
.ic v(n431)=1.8
.ic v(n433)=1.8
.ic v(n435)=1.8
.ic v(n437)=1.8
.ic v(n439)=1.8
.ic v(n441)=1.8
.ic v(n443)=1.8
.ic v(n445)=1.8
.ic v(n447)=1.8
.ic v(n449)=1.8
.ic v(n451)=1.8
.ic v(n453)=1.8
.ic v(n455)=1.8
.ic v(n457)=1.8
.ic v(n459)=1.8
.ic v(n461)=1.8
.ic v(n463)=1.8
.ic v(n465)=1.8
.ic v(n467)=1.8
.ic v(n469)=1.8
.ic v(n471)=1.8
.ic v(n473)=1.8
.ic v(n475)=1.8
.ic v(n477)=1.8
.ic v(n479)=1.8
.ic v(n481)=1.8
.ic v(n483)=1.8
.ic v(n485)=1.8
.ic v(n487)=1.8
.ic v(n489)=1.8
.ic v(n491)=1.8
.ic v(n493)=1.8
.ic v(n495)=1.8
.ic v(n497)=1.8
.ic v(n499)=1.8
.ic v(n501)=1.8
.ic v(n503)=1.8
.ic v(n505)=1.8
.ic v(n507)=1.8
.ic v(n509)=1.8
.ic v(n511)=1.8
.ic v(n513)=1.8
.ic v(n515)=1.8
.ic v(n517)=1.8
.ic v(n519)=1.8
.ic v(n521)=1.8
.ic v(n523)=1.8
.ic v(n525)=1.8
.ic v(n527)=1.8
.ic v(n529)=1.8
.ic v(n531)=1.8
.ic v(n533)=1.8
.ic v(n535)=1.8
.ic v(n537)=1.8
.ic v(n539)=1.8
.ic v(n541)=1.8
.ic v(n543)=1.8
.ic v(n545)=1.8
.ic v(n547)=1.8
.ic v(n549)=1.8
.ic v(n551)=1.8
.ic v(n553)=1.8
.ic v(n555)=1.8
.ic v(n557)=1.8
.ic v(n559)=1.8
.ic v(n561)=1.8
.ic v(n563)=1.8
.ic v(n565)=1.8
.ic v(n567)=1.8
.ic v(n569)=1.8
.ic v(n571)=1.8
.ic v(n573)=1.8
.ic v(n575)=1.8
.ic v(n577)=1.8
.ic v(n579)=1.8
.ic v(n581)=1.8
.ic v(n583)=1.8
.ic v(n585)=1.8
.ic v(n587)=1.8
.ic v(n589)=1.8
.ic v(n591)=1.8
.ic v(n593)=1.8
.ic v(n595)=1.8
.ic v(n597)=1.8
.ic v(n599)=1.8
.ic v(n601)=1.8
.ic v(n603)=1.8
.ic v(n605)=1.8
.ic v(n607)=1.8
.ic v(n609)=1.8
.ic v(n611)=1.8
.ic v(n613)=1.8
.ic v(n615)=1.8
.ic v(n617)=1.8
.ic v(n619)=1.8
.ic v(n621)=1.8
.ic v(n623)=1.8
.ic v(n625)=1.8
.ic v(n627)=1.8
.ic v(n629)=1.8
.ic v(n631)=1.8
.ic v(n633)=1.8
.ic v(n635)=1.8
.ic v(n637)=1.8
.ic v(n639)=1.8
.ic v(n641)=1.8
.ic v(n643)=1.8
.ic v(n645)=1.8
.ic v(n647)=1.8
.ic v(n649)=1.8
.ic v(n651)=1.8
.ic v(n653)=1.8
.ic v(n655)=1.8
.ic v(n657)=1.8
.ic v(n659)=1.8
.ic v(n661)=1.8
.ic v(n663)=1.8
.ic v(n665)=1.8
.ic v(n667)=1.8
.ic v(n669)=1.8
.ic v(n671)=1.8
.ic v(n673)=1.8
.ic v(n675)=1.8
.ic v(n677)=1.8
.ic v(n679)=1.8
.ic v(n681)=1.8
.ic v(n683)=1.8
.ic v(n685)=1.8
.ic v(n687)=1.8
.ic v(n689)=1.8
.ic v(n691)=1.8
.ic v(n693)=1.8
.ic v(n695)=1.8
.ic v(n697)=1.8
.ic v(n699)=1.8
.ic v(n701)=1.8
.ic v(n703)=1.8
.ic v(n705)=1.8
.ic v(n707)=1.8
.ic v(n709)=1.8
.ic v(n711)=1.8
.ic v(n713)=1.8
.ic v(n715)=1.8
.ic v(n717)=1.8
.ic v(n719)=1.8
.ic v(n721)=1.8
.ic v(n723)=1.8
.ic v(n725)=1.8
.ic v(n727)=1.8
.ic v(n729)=1.8
.ic v(n731)=1.8
.ic v(n733)=1.8
.ic v(n735)=1.8
.ic v(n737)=1.8
.ic v(n739)=1.8
.ic v(n741)=1.8
.ic v(n743)=1.8
.ic v(n745)=1.8
.ic v(n747)=1.8
.ic v(n749)=1.8
.ic v(n751)=1.8
.ic v(n753)=1.8
.ic v(n755)=1.8
.ic v(n757)=1.8
.ic v(n759)=1.8
.ic v(n761)=1.8
.ic v(n763)=1.8
.ic v(n765)=1.8
.ic v(n767)=1.8
.ic v(n769)=1.8
.ic v(n771)=1.8
.ic v(n773)=1.8
.ic v(n775)=1.8
.ic v(n777)=1.8
.ic v(n779)=1.8
.ic v(n781)=1.8
.ic v(n783)=1.8
.ic v(n785)=1.8
.ic v(n787)=1.8
.ic v(n789)=1.8
.ic v(n791)=1.8
.ic v(n793)=1.8
.ic v(n795)=1.8
.ic v(n797)=1.8
.ic v(n799)=1.8
.ic v(n801)=1.8
.ic v(n803)=1.8
.ic v(n805)=1.8
.ic v(n807)=1.8
.ic v(n809)=1.8
.ic v(n811)=1.8
.ic v(n813)=1.8
.ic v(n815)=1.8
.ic v(n817)=1.8
.ic v(n819)=1.8
.ic v(n821)=1.8
.ic v(n823)=1.8
.ic v(n825)=1.8
.ic v(n827)=1.8
.ic v(n829)=1.8
.ic v(n831)=1.8
.ic v(n833)=1.8
.ic v(n835)=1.8
.ic v(n837)=1.8
.ic v(n839)=1.8
.ic v(n841)=1.8
.ic v(n843)=1.8
.ic v(n845)=1.8
.ic v(n847)=1.8
.ic v(n849)=1.8
.ic v(n851)=1.8
.ic v(n853)=1.8
.ic v(n855)=1.8
.ic v(n857)=1.8
.ic v(n859)=1.8
.ic v(n861)=1.8
.ic v(n863)=1.8
.ic v(n865)=1.8
.ic v(n867)=1.8
.ic v(n869)=1.8
.ic v(n871)=1.8
.ic v(n873)=1.8
.ic v(n875)=1.8
.ic v(n877)=1.8
.ic v(n879)=1.8
.ic v(n881)=1.8
.ic v(n883)=1.8
.ic v(n885)=1.8
.ic v(n887)=1.8
.ic v(n889)=1.8
.ic v(n891)=1.8
.ic v(n893)=1.8
.ic v(n895)=1.8
.ic v(n897)=1.8
.ic v(n899)=1.8
.ic v(n901)=1.8
.ic v(n903)=1.8
.ic v(n905)=1.8
.ic v(n907)=1.8
.ic v(n909)=1.8
.ic v(n911)=1.8
.ic v(n913)=1.8
.ic v(n915)=1.8
.ic v(n917)=1.8
.ic v(n919)=1.8
.ic v(n921)=1.8
.ic v(n923)=1.8
.ic v(n925)=1.8
.ic v(n927)=1.8
.ic v(n929)=1.8
.ic v(n931)=1.8
.ic v(n933)=1.8
.ic v(n935)=1.8
.ic v(n937)=1.8
.ic v(n939)=1.8
.ic v(n941)=1.8
.ic v(n943)=1.8
.ic v(n945)=1.8
.ic v(n947)=1.8
.ic v(n949)=1.8
.ic v(n951)=1.8
.ic v(n953)=1.8
.ic v(n955)=1.8
.ic v(n957)=1.8
.ic v(n959)=1.8
.ic v(n961)=1.8
.ic v(n963)=1.8
.ic v(n965)=1.8
.ic v(n967)=1.8
.ic v(n969)=1.8
.ic v(n971)=1.8
.ic v(n973)=1.8
.ic v(n975)=1.8
.ic v(n977)=1.8
.ic v(n979)=1.8
.ic v(n981)=1.8
.ic v(n983)=1.8
.ic v(n985)=1.8
.ic v(n987)=1.8
.ic v(n989)=1.8
.ic v(n991)=1.8
.ic v(n993)=1.8
.ic v(n995)=1.8
.ic v(n997)=1.8
.ic v(n999)=1.8
.options method=gear
.tran 20p 1n uic
.save v(n0) v(n500) v(n1000)
.end
